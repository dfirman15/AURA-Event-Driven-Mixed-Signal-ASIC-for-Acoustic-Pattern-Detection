* Extracted by KLayout with GF180MCU LVS runset on : 01/09/2026 12:48

.SUBCKT B04_TOP VDD Vbpf Venvelope Vin Vthreshold Vtrigger en sda_out sda_oe
+ sda_in scl GND
X$1 Venvelope Vbpf VDD Vin \$25 \$26 \$39 Vthreshold \$20 GND B04_AFE_top
X$3 \$20 \$39 \$26 \$25 VDD en scl \$69 sda_in sda_out sda_oe Vtrigger GND
+ digital_top
X$109 en \$69 VDD GND B04_clock_gen
.ENDS B04_TOP

.SUBCKT digital_top comp_out cap_ctrl[0] cap_ctrl[1] cap_ctrl[2] VDD en scl clk
+ sda_in sda_out sda_oe trigger_out VSS
X$1 comp_out VDD VSS \$9 VDD VSS gf180mcu_fd_sc_mcu7t5v0__dlyb_1
X$2 \$48 VDD VSS cap_ctrl[0] VDD VSS gf180mcu_fd_sc_mcu7t5v0__dlyb_1
X$3 \$40 VDD VSS cap_ctrl[1] VDD VSS gf180mcu_fd_sc_mcu7t5v0__dlyb_1
X$4 \$11 VDD VSS cap_ctrl[2] VDD VSS gf180mcu_fd_sc_mcu7t5v0__dlyb_1
X$5 VSS VDD \$6 \$66 VDD VSS gf180mcu_fd_sc_mcu7t5v0__clkinv_1
X$6 VSS VDD \$6 \$155 VDD VSS gf180mcu_fd_sc_mcu7t5v0__clkinv_1
X$7 VSS VDD \$6 \$78 VDD VSS gf180mcu_fd_sc_mcu7t5v0__clkinv_1
X$8 VSS VDD \$6 \$152 VDD VSS gf180mcu_fd_sc_mcu7t5v0__clkinv_1
X$9 \$27 VDD VSS \$6 VDD VSS gf180mcu_fd_sc_mcu7t5v0__dlyb_1
X$10 \$6 VDD VSS \$10 VDD VSS gf180mcu_fd_sc_mcu7t5v0__dlyb_1
X$11 \$38 VDD VSS \$7 VDD VSS gf180mcu_fd_sc_mcu7t5v0__dlyb_1
X$12 \$7 VDD VSS \$12 VDD VSS gf180mcu_fd_sc_mcu7t5v0__dlyb_1
X$13 \$7 VDD VSS \$84 VDD VSS gf180mcu_fd_sc_mcu7t5v0__dlyb_1
X$14 \$7 VDD VSS \$258 VDD VSS gf180mcu_fd_sc_mcu7t5v0__dlyb_1
X$15 \$7 VDD VSS \$135 VDD VSS gf180mcu_fd_sc_mcu7t5v0__dlyb_1
X$16 VSS VDD VDD VSS gf180mcu_fd_sc_mcu7t5v0__fillcap_64
X$17 VSS VDD VDD VSS gf180mcu_fd_sc_mcu7t5v0__fillcap_64
X$18 VSS VDD VDD VSS gf180mcu_fd_sc_mcu7t5v0__fillcap_64
X$19 VSS VDD VDD VSS gf180mcu_fd_sc_mcu7t5v0__fillcap_64
X$20 VSS VDD VDD VSS gf180mcu_fd_sc_mcu7t5v0__fillcap_64
X$21 VSS VDD VDD VSS gf180mcu_fd_sc_mcu7t5v0__fillcap_64
X$22 VSS VDD VDD VSS gf180mcu_fd_sc_mcu7t5v0__fillcap_64
X$23 VSS VDD VDD VSS gf180mcu_fd_sc_mcu7t5v0__fillcap_64
X$24 VSS VDD VDD VSS gf180mcu_fd_sc_mcu7t5v0__fillcap_64
X$25 VSS VDD VDD VSS gf180mcu_fd_sc_mcu7t5v0__fillcap_64
X$26 VSS VDD VDD VSS gf180mcu_fd_sc_mcu7t5v0__fillcap_64
X$27 VSS VDD VDD VSS gf180mcu_fd_sc_mcu7t5v0__fillcap_64
X$28 VSS VDD VDD VSS gf180mcu_fd_sc_mcu7t5v0__fillcap_64
X$29 VSS VDD VDD VSS gf180mcu_fd_sc_mcu7t5v0__fillcap_64
X$30 VSS VDD VDD VSS gf180mcu_fd_sc_mcu7t5v0__fillcap_64
X$31 VSS VDD VDD VSS gf180mcu_fd_sc_mcu7t5v0__fillcap_64
X$32 VSS VDD VDD VSS gf180mcu_fd_sc_mcu7t5v0__fillcap_64
X$33 VSS VDD VDD VSS gf180mcu_fd_sc_mcu7t5v0__fillcap_64
X$34 VSS VDD VDD VSS gf180mcu_fd_sc_mcu7t5v0__fillcap_64
X$35 VSS VDD VDD VSS gf180mcu_fd_sc_mcu7t5v0__fillcap_64
X$36 VSS VDD VDD VSS gf180mcu_fd_sc_mcu7t5v0__fillcap_64
X$37 VSS VDD VDD VSS gf180mcu_fd_sc_mcu7t5v0__fillcap_64
X$38 VSS VDD VDD VSS gf180mcu_fd_sc_mcu7t5v0__fillcap_64
X$39 VSS VDD VDD VSS gf180mcu_fd_sc_mcu7t5v0__fillcap_64
X$40 VSS VDD VDD VSS gf180mcu_fd_sc_mcu7t5v0__fillcap_64
X$41 \$546 VSS VDD \$564 VDD VSS gf180mcu_fd_sc_mcu7t5v0__clkbuf_1
X$42 VSS VDD \$538 \$540 \$546 \$458 \$520 VDD VSS
+ gf180mcu_fd_sc_mcu7t5v0__oai31_1
X$43 \$570 VSS \$532 \$533 VDD \$538 VDD VSS gf180mcu_fd_sc_mcu7t5v0__or3_1
X$44 VSS VDD \$493 \$452 \$344 \$365 \$397 VDD VSS
+ gf180mcu_fd_sc_mcu7t5v0__nand4_1
X$45 VSS \$324 VDD \$365 \$345 \$383 \$328 \$267 VDD VSS
+ gf180mcu_fd_sc_mcu7t5v0__aoi221_1
X$46 VSS \$373 \$437 VDD \$381 VDD VSS gf180mcu_fd_sc_mcu7t5v0__xor2_1
X$47 VSS \$279 \$210 VDD \$287 VDD VSS gf180mcu_fd_sc_mcu7t5v0__xor2_1
X$48 VSS \$452 \$424 VDD \$446 VDD VSS gf180mcu_fd_sc_mcu7t5v0__xor2_1
X$49 VSS \$477 \$397 VDD \$469 VDD VSS gf180mcu_fd_sc_mcu7t5v0__xor2_1
X$50 VSS \$500 \$365 VDD \$501 VDD VSS gf180mcu_fd_sc_mcu7t5v0__xor2_1
X$51 VSS \$440 \$392 VDD \$448 VDD VSS gf180mcu_fd_sc_mcu7t5v0__xor2_1
X$52 VSS \$344 \$312 VDD \$345 VDD VSS gf180mcu_fd_sc_mcu7t5v0__xor2_1
X$53 VSS \$251 \$382 VDD \$411 VDD VSS gf180mcu_fd_sc_mcu7t5v0__xor2_1
X$54 VSS \$384 \$366 VDD \$385 VDD VSS gf180mcu_fd_sc_mcu7t5v0__xor2_1
X$55 VSS \$392 \$357 \$358 \$351 VDD VDD VSS gf180mcu_fd_sc_mcu7t5v0__dffsnq_1
X$56 VSS \$234 \$194 \$224 \$255 VDD VDD VSS gf180mcu_fd_sc_mcu7t5v0__dffsnq_1
X$57 VSS \$518 \$471 \$582 \$583 VDD VDD VSS gf180mcu_fd_sc_mcu7t5v0__dffsnq_1
X$58 VSS \$430 \$357 \$392 \$429 VDD VDD VSS gf180mcu_fd_sc_mcu7t5v0__dffsnq_1
X$59 VSS \$373 \$337 \$408 \$409 VDD VDD VSS gf180mcu_fd_sc_mcu7t5v0__dffsnq_1
X$60 VSS \$474 \$537 \$486 \$418 VDD VDD VSS gf180mcu_fd_sc_mcu7t5v0__dffsnq_1
X$61 VSS \$183 \$170 \$192 \$180 VDD VDD VSS gf180mcu_fd_sc_mcu7t5v0__dffsnq_1
X$62 VSS \$361 \$337 \$359 \$378 VDD VDD VSS gf180mcu_fd_sc_mcu7t5v0__dffsnq_1
X$63 VDD \$321 \$362 \$339 \$338 VSS VDD VSS gf180mcu_fd_sc_mcu7t5v0__oai21_1
X$64 VDD \$264 \$320 \$190 \$305 VSS VDD VSS gf180mcu_fd_sc_mcu7t5v0__oai21_1
X$65 VDD \$191 \$192 \$190 \$193 VSS VDD VSS gf180mcu_fd_sc_mcu7t5v0__oai21_1
X$66 VDD \$332 \$313 \$324 \$323 VSS VDD VSS gf180mcu_fd_sc_mcu7t5v0__oai21_1
X$67 VDD \$205 \$224 \$240 \$249 VSS VDD VSS gf180mcu_fd_sc_mcu7t5v0__oai21_1
X$68 VDD \$256 \$296 \$295 \$277 VSS VDD VSS gf180mcu_fd_sc_mcu7t5v0__oai21_1
X$69 VDD \$481 \$489 \$482 \$462 VSS VDD VSS gf180mcu_fd_sc_mcu7t5v0__oai21_1
X$70 VDD \$203 \$247 \$240 \$241 VSS VDD VSS gf180mcu_fd_sc_mcu7t5v0__oai21_1
X$71 VDD \$166 \$167 \$174 \$175 VSS VDD VSS gf180mcu_fd_sc_mcu7t5v0__oai21_1
X$72 VDD \$321 \$283 \$301 \$307 VSS VDD VSS gf180mcu_fd_sc_mcu7t5v0__oai21_1
X$73 VDD \$545 \$511 \$481 \$543 VSS VDD VSS gf180mcu_fd_sc_mcu7t5v0__oai21_1
X$74 VSS \$209 VDD \$210 \$175 \$173 \$172 VDD VSS
+ gf180mcu_fd_sc_mcu7t5v0__aoi22_1
X$75 VSS \$454 VDD \$481 \$434 \$512 \$485 VDD VSS
+ gf180mcu_fd_sc_mcu7t5v0__aoi22_1
X$76 VSS \$145 VDD \$132 \$174 \$196 \$216 VDD VSS
+ gf180mcu_fd_sc_mcu7t5v0__aoi22_1
X$77 VSS \$295 VDD \$397 \$410 \$366 \$339 VDD VSS
+ gf180mcu_fd_sc_mcu7t5v0__aoi22_1
X$78 VSS \$105 \$50 VDD VDD VSS gf180mcu_fd_sc_mcu7t5v0__clkbuf_8
X$79 VSS \$105 \$194 VDD VDD VSS gf180mcu_fd_sc_mcu7t5v0__clkbuf_8
X$80 VSS \$105 \$325 VDD VDD VSS gf180mcu_fd_sc_mcu7t5v0__clkbuf_8
X$81 VSS \$105 \$29 VDD VDD VSS gf180mcu_fd_sc_mcu7t5v0__clkbuf_8
X$82 VSS \$105 \$357 VDD VDD VSS gf180mcu_fd_sc_mcu7t5v0__clkbuf_8
X$83 VSS \$105 \$170 VDD VDD VSS gf180mcu_fd_sc_mcu7t5v0__clkbuf_8
X$84 VSS \$105 \$186 VDD VDD VSS gf180mcu_fd_sc_mcu7t5v0__clkbuf_8
X$85 VSS \$105 \$537 VDD VDD VSS gf180mcu_fd_sc_mcu7t5v0__clkbuf_8
X$86 VSS \$105 \$496 VDD VDD VSS gf180mcu_fd_sc_mcu7t5v0__clkbuf_8
X$87 VSS \$105 \$337 VDD VDD VSS gf180mcu_fd_sc_mcu7t5v0__clkbuf_8
X$88 VSS \$105 \$471 VDD VDD VSS gf180mcu_fd_sc_mcu7t5v0__clkbuf_8
X$89 VSS \$455 \$485 VDD \$435 VDD VSS gf180mcu_fd_sc_mcu7t5v0__or2_1
X$90 VSS \$105 \$404 VDD VDD VSS gf180mcu_fd_sc_mcu7t5v0__clkbuf_8
X$91 VSS \$105 \$82 VDD VDD VSS gf180mcu_fd_sc_mcu7t5v0__clkbuf_8
X$92 VSS \$105 \$478 VDD VDD VSS gf180mcu_fd_sc_mcu7t5v0__clkbuf_8
X$93 VSS \$105 \$243 VDD VDD VSS gf180mcu_fd_sc_mcu7t5v0__clkbuf_8
X$94 VDD \$402 \$515 VSS \$485 VDD VSS gf180mcu_fd_sc_mcu7t5v0__and2_1
X$95 VDD \$463 \$423 VSS \$457 VDD VSS gf180mcu_fd_sc_mcu7t5v0__and2_1
X$96 VDD \$129 \$140 VSS \$141 VDD VSS gf180mcu_fd_sc_mcu7t5v0__and2_1
X$97 VDD \$175 \$174 VSS \$161 VDD VSS gf180mcu_fd_sc_mcu7t5v0__and2_1
X$98 VDD \$132 \$113 VSS \$142 VDD VSS gf180mcu_fd_sc_mcu7t5v0__and2_1
X$99 VDD \$422 \$445 VSS \$431 VDD VSS gf180mcu_fd_sc_mcu7t5v0__and2_1
X$100 VDD \$462 \$482 VSS \$318 VDD VSS gf180mcu_fd_sc_mcu7t5v0__and2_1
X$101 VSS VDD \$237 \$36 \$304 \$246 VDD VSS gf180mcu_fd_sc_mcu7t5v0__nand3_1
X$102 VSS VDD \$493 \$477 \$344 \$365 VDD VSS gf180mcu_fd_sc_mcu7t5v0__nand3_1
X$103 VSS VDD \$586 \$553 \$573 \$569 VDD VSS gf180mcu_fd_sc_mcu7t5v0__nand3_1
X$104 VSS VDD \$237 \$239 \$238 \$231 VDD VSS gf180mcu_fd_sc_mcu7t5v0__nand3_1
X$105 VSS VDD \$142 \$217 \$216 \$210 VDD VSS gf180mcu_fd_sc_mcu7t5v0__nand3_1
X$106 VSS \$551 \$567 \$543 \$558 \$570 VDD VDD VSS
+ gf180mcu_fd_sc_mcu7t5v0__aoi211_1
X$107 VSS \$551 \$554 \$506 \$558 \$570 VDD VDD VSS
+ gf180mcu_fd_sc_mcu7t5v0__aoi211_1
X$108 VSS VDD \$251 \$405 \$384 VDD VSS gf180mcu_fd_sc_mcu7t5v0__nand2_1
X$109 VSS VDD \$142 \$216 \$279 VDD VSS gf180mcu_fd_sc_mcu7t5v0__nand2_1
X$110 VSS VDD \$103 \$204 \$241 VDD VSS gf180mcu_fd_sc_mcu7t5v0__nand2_1
X$111 VSS VDD \$264 \$154 \$305 VDD VSS gf180mcu_fd_sc_mcu7t5v0__nand2_1
X$112 VSS VDD \$262 \$261 \$551 VDD VSS gf180mcu_fd_sc_mcu7t5v0__nand2_1
X$113 VSS VDD \$434 \$221 \$432 VDD VSS gf180mcu_fd_sc_mcu7t5v0__nand2_1
X$114 VSS VDD \$485 \$475 \$494 VDD VSS gf180mcu_fd_sc_mcu7t5v0__nand2_1
X$115 VSS VDD \$111 \$128 \$140 VDD VSS gf180mcu_fd_sc_mcu7t5v0__nand2_1
X$116 VDD \$100 \$141 \$148 \$161 \$149 VSS VDD VSS
+ gf180mcu_fd_sc_mcu7t5v0__oai211_1
X$117 VSS VDD \$482 \$454 \$221 VDD VSS gf180mcu_fd_sc_mcu7t5v0__nand2_1
X$118 VSS VDD \$555 \$560 \$561 VDD VSS gf180mcu_fd_sc_mcu7t5v0__nand2_1
X$119 VSS VDD \$99 \$121 \$93 VDD VSS gf180mcu_fd_sc_mcu7t5v0__nand2_1
X$120 VSS VDD \$363 \$328 \$329 VDD VSS gf180mcu_fd_sc_mcu7t5v0__nand2_1
X$121 VSS VDD \$485 \$484 \$480 VDD VSS gf180mcu_fd_sc_mcu7t5v0__nand2_1
X$122 VSS VDD \$486 \$474 \$441 VDD VSS gf180mcu_fd_sc_mcu7t5v0__nand2_1
X$123 VSS VDD \$511 \$494 \$510 VDD VSS gf180mcu_fd_sc_mcu7t5v0__nand2_1
X$124 VSS VDD \$74 \$87 \$99 VDD VSS gf180mcu_fd_sc_mcu7t5v0__nand2_1
X$125 VSS VDD \$191 \$183 \$193 VDD VSS gf180mcu_fd_sc_mcu7t5v0__nand2_1
X$126 VSS VDD \$531 \$555 \$558 VDD VSS gf180mcu_fd_sc_mcu7t5v0__nand2_1
X$127 VSS VDD \$55 \$72 \$74 VDD VSS gf180mcu_fd_sc_mcu7t5v0__nand2_1
X$128 VSS VDD \$327 \$340 \$342 VDD VSS gf180mcu_fd_sc_mcu7t5v0__nand2_1
X$129 VSS VDD \$332 \$236 \$338 VDD VSS gf180mcu_fd_sc_mcu7t5v0__nand2_1
X$130 VSS VDD \$515 \$552 \$549 VDD VSS gf180mcu_fd_sc_mcu7t5v0__nand2_1
X$131 VSS VDD \$256 \$204 \$277 VDD VSS gf180mcu_fd_sc_mcu7t5v0__nand2_1
X$132 VSS VDD \$332 \$322 \$323 VDD VSS gf180mcu_fd_sc_mcu7t5v0__nand2_1
X$133 VSS VDD \$489 \$480 \$472 VDD VSS gf180mcu_fd_sc_mcu7t5v0__nand2_1
X$134 VSS VDD \$493 \$344 \$500 VDD VSS gf180mcu_fd_sc_mcu7t5v0__nand2_1
X$135 VSS VDD \$321 \$125 \$307 VDD VSS gf180mcu_fd_sc_mcu7t5v0__nand2_1
X$136 VSS VDD \$191 \$234 \$249 VDD VSS gf180mcu_fd_sc_mcu7t5v0__nand2_1
X$137 VSS VDD \$35 \$261 \$125 \$154 \$190 VDD VSS
+ gf180mcu_fd_sc_mcu7t5v0__nor4_1
X$138 VSS VDD \$176 \$168 \$142 \$13 \$23 VDD VSS
+ gf180mcu_fd_sc_mcu7t5v0__nor4_1
X$139 VSS VDD \$284 \$327 \$312 \$308 \$315 VDD VSS
+ gf180mcu_fd_sc_mcu7t5v0__nor4_1
X$140 VSS VDD \$204 \$262 \$240 \$44 \$106 VDD VSS
+ gf180mcu_fd_sc_mcu7t5v0__nor4_1
X$141 VSS VDD \$457 \$450 \$467 \$468 \$375 VDD VSS
+ gf180mcu_fd_sc_mcu7t5v0__nor4_1
X$142 VSS VDD \$476 \$497 \$499 \$286 \$375 VDD VSS
+ gf180mcu_fd_sc_mcu7t5v0__nor4_1
X$143 \$499 VSS VDD \$493 VDD VSS gf180mcu_fd_sc_mcu7t5v0__clkbuf_1
X$144 VSS VDD \$374 \$334 \$329 \$354 \$343 VDD VSS
+ gf180mcu_fd_sc_mcu7t5v0__nor4_1
X$145 VSS VDD \$101 \$112 \$113 \$13 \$23 VDD VSS
+ gf180mcu_fd_sc_mcu7t5v0__nor4_1
X$146 VSS VDD \$171 \$158 \$183 \$184 \$234 VDD VSS
+ gf180mcu_fd_sc_mcu7t5v0__nor4_1
X$147 VDD \$584 VSS \$435 \$578 \$593 \$561 VDD VSS
+ gf180mcu_fd_sc_mcu7t5v0__oai22_1
X$148 VDD \$579 VSS \$435 \$506 \$571 \$561 VDD VSS
+ gf180mcu_fd_sc_mcu7t5v0__oai22_1
X$149 VDD \$118 VSS \$71 \$126 \$110 \$120 VDD VSS
+ gf180mcu_fd_sc_mcu7t5v0__oai22_1
X$150 VDD \$573 VSS \$580 \$564 \$587 \$552 VDD VSS
+ gf180mcu_fd_sc_mcu7t5v0__oai22_1
X$151 VDD \$145 VSS \$132 \$173 \$185 \$172 VDD VSS
+ gf180mcu_fd_sc_mcu7t5v0__oai22_1
X$152 VDD \$196 VSS \$216 \$209 \$166 \$210 VDD VSS
+ gf180mcu_fd_sc_mcu7t5v0__oai22_1
X$153 VSS \$217 \$172 VDD \$235 VDD VSS gf180mcu_fd_sc_mcu7t5v0__xor2_1
X$154 VDD \$91 VSS \$87 \$128 \$129 \$111 VDD VSS
+ gf180mcu_fd_sc_mcu7t5v0__oai22_1
X$155 VDD \$564 VSS \$549 \$534 \$541 \$565 VDD VSS
+ gf180mcu_fd_sc_mcu7t5v0__oai22_1
X$156 VSS \$580 \$598 \$573 \$587 VDD VDD VSS gf180mcu_fd_sc_mcu7t5v0__aoi21_1
X$157 VSS \$52 \$61 \$69 \$53 VDD VDD VSS gf180mcu_fd_sc_mcu7t5v0__aoi21_1
X$158 VSS \$580 \$581 \$573 \$569 VDD VDD VSS gf180mcu_fd_sc_mcu7t5v0__aoi21_1
X$159 VSS \$558 \$559 \$570 \$554 VDD VDD VSS gf180mcu_fd_sc_mcu7t5v0__aoi21_1
X$160 VSS \$256 \$266 \$240 \$257 VDD VDD VSS gf180mcu_fd_sc_mcu7t5v0__aoi21_1
X$161 VSS \$52 \$146 \$126 \$134 VDD VDD VSS gf180mcu_fd_sc_mcu7t5v0__aoi21_1
X$162 VSS \$191 \$156 \$145 \$179 VDD VDD VSS gf180mcu_fd_sc_mcu7t5v0__aoi21_1
X$163 VSS \$553 \$565 \$552 \$564 VDD VDD VSS gf180mcu_fd_sc_mcu7t5v0__aoi21_1
X$164 VSS \$117 \$108 \$118 \$116 VDD VDD VSS gf180mcu_fd_sc_mcu7t5v0__aoi21_1
X$165 VSS \$221 \$232 \$231 \$230 VDD VDD VSS gf180mcu_fd_sc_mcu7t5v0__aoi21_1
X$166 VSS \$221 \$281 \$304 \$298 VDD VDD VSS gf180mcu_fd_sc_mcu7t5v0__aoi21_1
X$167 VSS \$205 \$195 \$209 \$182 VDD VDD VSS gf180mcu_fd_sc_mcu7t5v0__aoi21_1
X$168 VSS \$342 \$343 \$383 \$267 VDD VDD VSS gf180mcu_fd_sc_mcu7t5v0__aoi21_1
X$169 VDD \$382 VSS \$361 \$354 \$410 \$339 \$366 VDD VSS
+ gf180mcu_fd_sc_mcu7t5v0__oai221_1
X$170 VSS \$203 \$215 \$190 \$208 VDD VDD VSS gf180mcu_fd_sc_mcu7t5v0__aoi21_1
X$171 \$29 VDD VSS VDD VSS gf180mcu_fd_sc_mcu7t5v0__clkbuf_2
X$172 \$478 VDD VSS VDD VSS gf180mcu_fd_sc_mcu7t5v0__clkbuf_2
X$173 \$170 VDD VSS VDD VSS gf180mcu_fd_sc_mcu7t5v0__clkbuf_2
X$174 \$404 VDD VSS VDD VSS gf180mcu_fd_sc_mcu7t5v0__clkbuf_2
X$175 \$537 VDD VSS VDD VSS gf180mcu_fd_sc_mcu7t5v0__clkbuf_2
X$176 \$186 VDD VSS VDD VSS gf180mcu_fd_sc_mcu7t5v0__clkbuf_2
X$177 \$325 VDD VSS VDD VSS gf180mcu_fd_sc_mcu7t5v0__clkbuf_2
X$178 \$82 VDD VSS VDD VSS gf180mcu_fd_sc_mcu7t5v0__clkbuf_2
X$179 \$496 VDD VSS VDD VSS gf180mcu_fd_sc_mcu7t5v0__clkbuf_2
X$180 \$194 VDD VSS VDD VSS gf180mcu_fd_sc_mcu7t5v0__clkbuf_2
X$181 \$471 VDD VSS VDD VSS gf180mcu_fd_sc_mcu7t5v0__clkbuf_2
X$182 \$243 VDD VSS VDD VSS gf180mcu_fd_sc_mcu7t5v0__clkbuf_2
X$183 \$59 VDD VSS VDD VSS gf180mcu_fd_sc_mcu7t5v0__clkbuf_2
X$184 VDD \$344 VSS \$517 \$499 VDD VSS gf180mcu_fd_sc_mcu7t5v0__xnor2_1
X$185 VDD \$216 VSS \$278 \$142 VDD VSS gf180mcu_fd_sc_mcu7t5v0__xnor2_1
X$186 VSS VDD \$455 \$559 \$577 VDD VSS gf180mcu_fd_sc_mcu7t5v0__nor2_1
X$187 VSS VDD \$581 \$565 \$574 VDD VSS gf180mcu_fd_sc_mcu7t5v0__nor2_1
X$188 VSS VDD \$553 \$524 \$515 VDD VSS gf180mcu_fd_sc_mcu7t5v0__nor2_1
X$189 VSS VDD \$564 \$568 \$580 VDD VSS gf180mcu_fd_sc_mcu7t5v0__nor2_1
X$190 VSS VDD \$567 \$589 \$582 VDD VSS gf180mcu_fd_sc_mcu7t5v0__nor2_1
X$191 VSS VDD \$185 \$166 \$149 VDD VSS gf180mcu_fd_sc_mcu7t5v0__nor2_1
X$192 VDD \$172 \$160 \$173 \$167 VSS VDD VSS gf180mcu_fd_sc_mcu7t5v0__oai21_1
X$193 VSS VDD \$221 \$236 \$230 VDD VSS gf180mcu_fd_sc_mcu7t5v0__nor2_1
X$194 VSS VDD \$448 \$441 \$455 VDD VSS gf180mcu_fd_sc_mcu7t5v0__nor2_1
X$195 VSS VDD \$256 \$267 \$257 VDD VSS gf180mcu_fd_sc_mcu7t5v0__nor2_1
X$196 VSS VDD \$462 \$454 \$506 VDD VSS gf180mcu_fd_sc_mcu7t5v0__nor2_1
X$197 VSS VDD \$467 \$380 \$476 VDD VSS gf180mcu_fd_sc_mcu7t5v0__nor2_1
X$198 VSS VDD \$423 \$463 \$467 VDD VSS gf180mcu_fd_sc_mcu7t5v0__nor2_1
X$199 VSS VDD \$514 \$474 \$402 VDD VSS gf180mcu_fd_sc_mcu7t5v0__nor2_1
X$200 VSS VDD \$585 \$580 \$594 VDD VSS gf180mcu_fd_sc_mcu7t5v0__nor2_1
X$201 VSS VDD \$520 \$586 \$585 VDD VSS gf180mcu_fd_sc_mcu7t5v0__nor2_1
X$202 VSS VDD \$191 \$154 \$179 VDD VSS gf180mcu_fd_sc_mcu7t5v0__nor2_1
X$203 VSS VDD \$117 \$35 \$116 VDD VSS gf180mcu_fd_sc_mcu7t5v0__nor2_1
X$204 VSS VDD \$205 \$204 \$182 VDD VSS gf180mcu_fd_sc_mcu7t5v0__nor2_1
X$205 VSS VDD \$486 \$532 \$555 VDD VSS gf180mcu_fd_sc_mcu7t5v0__nor2_1
X$206 VSS VDD \$203 \$204 \$208 VDD VSS gf180mcu_fd_sc_mcu7t5v0__nor2_1
X$207 VSS VDD \$121 \$111 \$113 VDD VSS gf180mcu_fd_sc_mcu7t5v0__nor2_1
X$208 VSS VDD \$52 \$106 \$53 VDD VSS gf180mcu_fd_sc_mcu7t5v0__nor2_1
X$209 VSS VDD \$221 \$44 \$298 VDD VSS gf180mcu_fd_sc_mcu7t5v0__nor2_1
X$210 VSS VDD \$458 \$531 \$552 VDD VSS gf180mcu_fd_sc_mcu7t5v0__nor2_1
X$211 VSS VDD \$117 \$125 \$134 VDD VSS gf180mcu_fd_sc_mcu7t5v0__nor2_1
X$212 VSS \$158 VDD \$98 \$159 \$148 \$160 VDD VSS
+ gf180mcu_fd_sc_mcu7t5v0__aoi22_1
X$213 VSS VDD \$551 \$538 \$545 VDD VSS gf180mcu_fd_sc_mcu7t5v0__nor2_1
X$214 VSS VDD \$113 \$132 \$176 VDD VSS gf180mcu_fd_sc_mcu7t5v0__nor2_1
X$215 VSS VDD \$455 \$555 \$481 VDD VSS gf180mcu_fd_sc_mcu7t5v0__nor2_1
X$216 VSS \$566 \$569 \$478 \$574 VDD VDD VSS gf180mcu_fd_sc_mcu7t5v0__dffrnq_1
X$217 VSS \$449 \$475 \$496 \$442 VDD VDD VSS gf180mcu_fd_sc_mcu7t5v0__dffrnq_1
X$218 VSS VDD \$533 \$475 \$514 \$484 \$512 VDD VSS
+ gf180mcu_fd_sc_mcu7t5v0__oai31_1
X$219 VSS \$403 \$379 \$325 \$362 VDD VDD VSS gf180mcu_fd_sc_mcu7t5v0__dffrnq_1
X$220 VSS \$22 \$40 \$29 \$30 VDD VDD VSS gf180mcu_fd_sc_mcu7t5v0__dffrnq_1
X$221 VSS \$294 \$284 \$194 \$283 VDD VDD VSS gf180mcu_fd_sc_mcu7t5v0__dffrnq_1
X$222 VSS \$21 \$70 \$29 \$61 VDD VDD VSS gf180mcu_fd_sc_mcu7t5v0__dffrnq_1
X$223 VSS \$535 \$524 \$496 \$541 VDD VDD VSS gf180mcu_fd_sc_mcu7t5v0__dffrnq_1
X$224 VSS \$439 \$454 \$357 \$432 VDD VDD VSS gf180mcu_fd_sc_mcu7t5v0__dffrnq_1
X$225 VSS \$127 \$128 \$29 \$146 VDD VDD VSS gf180mcu_fd_sc_mcu7t5v0__dffrnq_1
X$226 VSS \$456 \$437 \$325 \$450 VDD VDD VSS gf180mcu_fd_sc_mcu7t5v0__dffrnq_1
X$227 VSS \$162 \$132 \$82 \$168 VDD VDD VSS gf180mcu_fd_sc_mcu7t5v0__dffrnq_1
X$228 VSS \$75 \$71 \$82 \$63 VDD VDD VSS gf180mcu_fd_sc_mcu7t5v0__dffrnq_1
X$229 VSS \$498 \$380 \$496 \$497 VDD VDD VSS gf180mcu_fd_sc_mcu7t5v0__dffrnq_1
X$230 VSS \$114 \$120 \$82 \$112 VDD VDD VSS gf180mcu_fd_sc_mcu7t5v0__dffrnq_1
X$231 VSS \$595 \$573 \$496 \$598 VDD VDD VSS gf180mcu_fd_sc_mcu7t5v0__dffrnq_1
X$232 VSS \$139 \$184 \$194 \$195 VDD VDD VSS gf180mcu_fd_sc_mcu7t5v0__dffrnq_1
X$233 VSS \$326 \$308 \$325 \$313 VDD VDD VSS gf180mcu_fd_sc_mcu7t5v0__dffrnq_1
X$234 VSS \$310 \$237 \$186 \$318 VDD VDD VSS gf180mcu_fd_sc_mcu7t5v0__dffrnq_1
X$235 VSS \$292 \$238 \$186 \$281 VDD VDD VSS gf180mcu_fd_sc_mcu7t5v0__dffrnq_1
X$236 \$231 VDD \$304 \$237 VSS \$275 VDD VSS gf180mcu_fd_sc_mcu7t5v0__and3_1
X$237 VSS \$544 \$543 \$471 \$510 VDD VDD VSS gf180mcu_fd_sc_mcu7t5v0__dffrnq_1
X$238 VSS \$219 \$172 \$243 \$225 VDD VDD VSS gf180mcu_fd_sc_mcu7t5v0__dffrnq_1
X$239 VSS \$483 \$462 \$471 \$472 VDD VDD VSS gf180mcu_fd_sc_mcu7t5v0__dffrnq_1
X$240 VSS \$214 \$246 \$186 \$232 VDD VDD VSS gf180mcu_fd_sc_mcu7t5v0__dffrnq_1
X$241 VSS \$597 \$512 \$537 \$593 VDD VDD VSS gf180mcu_fd_sc_mcu7t5v0__dffrnq_1
X$242 VSS \$470 \$397 \$478 \$461 VDD VDD VSS gf180mcu_fd_sc_mcu7t5v0__dffrnq_1
X$243 VSS \$252 \$216 \$243 \$259 VDD VDD VSS gf180mcu_fd_sc_mcu7t5v0__dffrnq_1
X$244 VSS \$78 \$97 \$59 \$89 VDD VDD VSS gf180mcu_fd_sc_mcu7t5v0__dffrnq_1
X$245 \$50 VDD VSS VDD VSS gf180mcu_fd_sc_mcu7t5v0__clkbuf_2
X$246 VSS \$503 \$365 \$478 \$502 VDD VDD VSS gf180mcu_fd_sc_mcu7t5v0__dffrnq_1
X$247 VSS \$601 \$562 \$471 \$577 VDD VDD VSS gf180mcu_fd_sc_mcu7t5v0__dffrnq_1
X$248 VSS \$66 \$48 \$59 \$47 VDD VDD VSS gf180mcu_fd_sc_mcu7t5v0__dffrnq_1
X$249 VSS \$317 \$210 \$243 \$285 VDD VDD VSS gf180mcu_fd_sc_mcu7t5v0__dffrnq_1
X$250 VSS \$202 \$204 \$170 \$215 VDD VDD VSS gf180mcu_fd_sc_mcu7t5v0__dffrnq_1
X$251 VSS \$406 \$405 \$404 \$399 VDD VDD VSS gf180mcu_fd_sc_mcu7t5v0__dffrnq_1
X$252 VSS \$377 \$282 \$357 \$393 VDD VDD VSS gf180mcu_fd_sc_mcu7t5v0__dffrnq_1
X$253 VSS \$355 \$366 \$404 \$367 VDD VDD VSS gf180mcu_fd_sc_mcu7t5v0__dffrnq_1
X$254 VSS \$420 \$419 \$404 \$422 VDD VDD VSS gf180mcu_fd_sc_mcu7t5v0__dffrnq_1
X$255 VSS VDD \$445 \$423 \$422 \$405 \$366 VDD VSS
+ gf180mcu_fd_sc_mcu7t5v0__nand4_1
X$256 VSS \$425 \$424 \$404 \$426 VDD VDD VSS gf180mcu_fd_sc_mcu7t5v0__dffrnq_1
X$257 VSS \$152 \$151 \$59 \$144 VDD VDD VSS gf180mcu_fd_sc_mcu7t5v0__dffrnq_1
X$258 VSS \$592 \$586 \$537 \$594 VDD VDD VSS gf180mcu_fd_sc_mcu7t5v0__dffrnq_1
X$259 VSS \$155 \$154 \$170 \$153 VDD VDD VSS gf180mcu_fd_sc_mcu7t5v0__dffrnq_1
X$260 VSS \$263 \$322 \$337 \$320 VDD VDD VSS gf180mcu_fd_sc_mcu7t5v0__dffrnq_1
X$261 VSS \$124 \$125 \$59 \$107 VDD VDD VSS gf180mcu_fd_sc_mcu7t5v0__dffrnq_1
X$262 VSS \$293 \$312 \$337 \$306 VDD VDD VSS gf180mcu_fd_sc_mcu7t5v0__dffrnq_1
X$263 VSS \$233 \$265 \$170 \$247 VDD VDD VSS gf180mcu_fd_sc_mcu7t5v0__dffrnq_1
X$264 VSS \$444 \$422 \$325 \$9 VDD VDD VSS gf180mcu_fd_sc_mcu7t5v0__dffrnq_1
X$265 VSS \$522 \$344 \$478 \$526 VDD VDD VSS gf180mcu_fd_sc_mcu7t5v0__dffrnq_1
X$266 VSS \$39 \$68 \$50 \$67 VDD VDD VSS gf180mcu_fd_sc_mcu7t5v0__dffrnq_1
X$267 VSS \$563 \$484 \$537 \$571 VDD VDD VSS gf180mcu_fd_sc_mcu7t5v0__dffrnq_1
X$268 VSS \$41 \$72 \$29 \$58 VDD VDD VSS gf180mcu_fd_sc_mcu7t5v0__dffrnq_1
X$269 VSS VDD \$55 \$121 \$72 \$71 VDD VSS gf180mcu_fd_sc_mcu7t5v0__nand3_1
X$270 VSS \$54 \$91 \$50 \$108 VDD VDD VSS gf180mcu_fd_sc_mcu7t5v0__dffrnq_1
X$271 VSS \$138 \$171 \$50 \$156 VDD VDD VSS gf180mcu_fd_sc_mcu7t5v0__dffrnq_1
X$272 VSS \$42 \$55 \$82 \$24 VDD VDD VSS gf180mcu_fd_sc_mcu7t5v0__dffrnq_1
X$273 VSS \$92 \$100 \$73 \$110 \$129 VDD VDD VSS
+ gf180mcu_fd_sc_mcu7t5v0__aoi211_1
X$274 VDD \$111 \$121 VSS \$101 VDD VSS gf180mcu_fd_sc_mcu7t5v0__and2_1
X$275 VSS \$303 \$315 \$243 \$296 VDD VDD VSS gf180mcu_fd_sc_mcu7t5v0__dffrnq_1
X$276 VSS \$268 \$267 \$194 \$266 VDD VDD VSS gf180mcu_fd_sc_mcu7t5v0__dffrnq_1
X$277 VSS VDD \$89 \$106 \$103 \$35 VDD VSS gf180mcu_fd_sc_mcu7t5v0__mux2_2
X$278 VSS \$105 \$59 VDD VDD VSS gf180mcu_fd_sc_mcu7t5v0__clkbuf_8
X$279 VSS VDD \$30 \$40 \$36 \$106 VDD VSS gf180mcu_fd_sc_mcu7t5v0__mux2_2
X$280 VDD \$51 VSS \$55 \$69 \$92 \$72 VDD VSS gf180mcu_fd_sc_mcu7t5v0__oai22_1
X$281 VSS VDD \$68 \$98 \$70 \$91 \$128 VDD VSS gf180mcu_fd_sc_mcu7t5v0__nor4_1
X$282 VSS VDD \$306 \$154 \$321 \$312 VDD VSS gf180mcu_fd_sc_mcu7t5v0__mux2_2
X$283 VSS VDD \$359 \$360 \$332 \$361 VDD VSS gf180mcu_fd_sc_mcu7t5v0__mux2_2
X$284 VSS VDD \$153 \$125 \$103 \$154 VDD VSS gf180mcu_fd_sc_mcu7t5v0__mux2_2
X$285 VSS VDD \$393 \$392 \$264 \$360 VDD VSS gf180mcu_fd_sc_mcu7t5v0__mux2_2
X$286 VSS VDD \$408 \$97 \$332 \$373 VDD VSS gf180mcu_fd_sc_mcu7t5v0__mux2_2
X$287 VSS VDD \$519 \$375 \$498 \$9 VDD VSS gf180mcu_fd_sc_mcu7t5v0__mux2_2
X$288 VSS VDD \$47 \$48 \$36 \$44 VDD VSS gf180mcu_fd_sc_mcu7t5v0__mux2_2
X$289 VSS VDD \$107 \$35 \$103 \$125 VDD VSS gf180mcu_fd_sc_mcu7t5v0__mux2_2
X$290 VSS VDD \$144 \$44 \$103 \$106 VDD VSS gf180mcu_fd_sc_mcu7t5v0__mux2_2
X$291 VSS \$20 \$11 \$50 \$37 VDD VDD VSS gf180mcu_fd_sc_mcu7t5v0__dffrnq_1
X$292 VSS \$117 \$67 \$51 \$28 VDD VDD VSS gf180mcu_fd_sc_mcu7t5v0__aoi21_1
X$293 VSS VDD VDD VSS gf180mcu_fd_sc_mcu7t5v0__fillcap_32
X$294 VSS VDD VDD VSS gf180mcu_fd_sc_mcu7t5v0__fillcap_32
X$295 VSS VDD VDD VSS gf180mcu_fd_sc_mcu7t5v0__fillcap_32
X$296 VSS VDD VDD VSS gf180mcu_fd_sc_mcu7t5v0__fillcap_32
X$297 VSS VDD VDD VSS gf180mcu_fd_sc_mcu7t5v0__fillcap_32
X$298 VSS VDD VDD VSS gf180mcu_fd_sc_mcu7t5v0__fillcap_32
X$299 VSS VDD VDD VSS gf180mcu_fd_sc_mcu7t5v0__fillcap_32
X$300 VSS VDD VDD VSS gf180mcu_fd_sc_mcu7t5v0__fillcap_32
X$301 VSS VDD VDD VSS gf180mcu_fd_sc_mcu7t5v0__fillcap_32
X$302 VSS VDD VDD VSS gf180mcu_fd_sc_mcu7t5v0__fillcap_32
X$303 VSS VDD VDD VSS gf180mcu_fd_sc_mcu7t5v0__fillcap_32
X$304 VSS VDD VDD VSS gf180mcu_fd_sc_mcu7t5v0__fillcap_32
X$305 VSS VDD VDD VSS gf180mcu_fd_sc_mcu7t5v0__fillcap_32
X$306 VSS VDD VDD VSS gf180mcu_fd_sc_mcu7t5v0__fillcap_32
X$307 VSS VDD VDD VSS gf180mcu_fd_sc_mcu7t5v0__fillcap_32
X$308 VSS VDD VDD VSS gf180mcu_fd_sc_mcu7t5v0__fillcap_32
X$309 VSS VDD VDD VSS gf180mcu_fd_sc_mcu7t5v0__fillcap_32
X$310 VSS VDD VDD VSS gf180mcu_fd_sc_mcu7t5v0__fillcap_32
X$311 VSS VDD VDD VSS gf180mcu_fd_sc_mcu7t5v0__fillcap_32
X$312 VSS VDD VDD VSS gf180mcu_fd_sc_mcu7t5v0__fillcap_32
X$313 VSS VDD VDD VSS gf180mcu_fd_sc_mcu7t5v0__fillcap_32
X$314 VSS VDD VDD VSS gf180mcu_fd_sc_mcu7t5v0__fillcap_32
X$315 VSS VDD VDD VSS gf180mcu_fd_sc_mcu7t5v0__fillcap_32
X$316 VSS VDD VDD VSS gf180mcu_fd_sc_mcu7t5v0__fillcap_32
X$317 VSS VDD VDD VSS gf180mcu_fd_sc_mcu7t5v0__fillcap_32
X$318 VSS VDD VDD VSS gf180mcu_fd_sc_mcu7t5v0__fillcap_32
X$319 VSS VDD VDD VSS gf180mcu_fd_sc_mcu7t5v0__fillcap_32
X$320 VSS VDD \$423 \$499 \$508 \$463 VDD VSS gf180mcu_fd_sc_mcu7t5v0__nor3_1
X$321 VSS VDD \$278 \$259 \$251 \$218 VDD VSS gf180mcu_fd_sc_mcu7t5v0__nor3_1
X$322 VSS VDD \$486 \$482 \$532 \$570 VDD VSS gf180mcu_fd_sc_mcu7t5v0__nor3_1
X$323 VSS VDD \$512 \$513 \$484 \$475 VDD VSS gf180mcu_fd_sc_mcu7t5v0__nor3_1
X$324 VSS VDD \$93 \$63 \$13 \$23 VDD VSS gf180mcu_fd_sc_mcu7t5v0__nor3_1
X$325 VSS VDD \$517 \$526 \$468 \$375 VDD VSS gf180mcu_fd_sc_mcu7t5v0__nor3_1
X$326 VSS VDD \$287 \$285 \$251 \$286 VDD VSS gf180mcu_fd_sc_mcu7t5v0__nor3_1
X$327 VSS VDD \$56 \$58 \$13 \$23 VDD VSS gf180mcu_fd_sc_mcu7t5v0__nor3_1
X$328 VSS VDD \$441 \$458 \$440 \$392 VDD VSS gf180mcu_fd_sc_mcu7t5v0__nor3_1
X$329 VSS VDD \$501 \$502 \$468 \$386 VDD VSS gf180mcu_fd_sc_mcu7t5v0__nor3_1
X$330 VSS VDD \$235 \$225 \$251 \$218 VDD VSS gf180mcu_fd_sc_mcu7t5v0__nor3_1
X$331 VSS VDD \$385 \$367 \$286 \$386 VDD VSS gf180mcu_fd_sc_mcu7t5v0__nor3_1
X$332 VSS VDD \$514 \$520 \$531 \$474 VDD VSS gf180mcu_fd_sc_mcu7t5v0__nor3_1
X$333 VSS VDD \$361 \$340 \$379 \$373 VDD VSS gf180mcu_fd_sc_mcu7t5v0__nor3_1
X$334 VSS VDD \$411 \$399 \$286 \$386 VDD VSS gf180mcu_fd_sc_mcu7t5v0__nor3_1
X$335 VSS VDD \$446 \$426 \$468 \$386 VDD VSS gf180mcu_fd_sc_mcu7t5v0__nor3_1
X$336 VSS VDD \$469 \$461 \$468 \$386 VDD VSS gf180mcu_fd_sc_mcu7t5v0__nor3_1
X$337 VSS VDD \$308 \$324 VDD VSS gf180mcu_fd_sc_mcu7t5v0__clkinv_1
X$338 VSS VDD \$474 \$532 VDD VSS gf180mcu_fd_sc_mcu7t5v0__clkinv_1
X$339 VSS VDD \$84 \$162 VDD VSS gf180mcu_fd_sc_mcu7t5v0__clkinv_1
X$340 VSS VDD \$84 \$75 VDD VSS gf180mcu_fd_sc_mcu7t5v0__clkinv_1
X$341 VSS VDD \$258 \$219 VDD VSS gf180mcu_fd_sc_mcu7t5v0__clkinv_1
X$342 VSS VDD \$169 \$292 VDD VSS gf180mcu_fd_sc_mcu7t5v0__clkinv_1
X$343 VSS VDD \$238 \$304 VDD VSS gf180mcu_fd_sc_mcu7t5v0__clkinv_1
X$344 VSS VDD \$84 \$114 VDD VSS gf180mcu_fd_sc_mcu7t5v0__clkinv_1
X$345 VSS VDD \$120 \$111 VDD VSS gf180mcu_fd_sc_mcu7t5v0__clkinv_1
X$346 VSS VDD \$223 \$293 VDD VSS gf180mcu_fd_sc_mcu7t5v0__clkinv_1
X$347 VSS VDD \$68 \$51 VDD VSS gf180mcu_fd_sc_mcu7t5v0__clkinv_1
X$348 VSS VDD \$10 \$54 VDD VSS gf180mcu_fd_sc_mcu7t5v0__clkinv_1
X$349 VSS VDD \$430 \$440 VDD VSS gf180mcu_fd_sc_mcu7t5v0__clkinv_1
X$350 VSS VDD \$352 \$444 VDD VSS gf180mcu_fd_sc_mcu7t5v0__clkinv_1
X$351 VSS VDD \$135 \$139 VDD VSS gf180mcu_fd_sc_mcu7t5v0__clkinv_1
X$352 VSS VDD \$10 \$138 VDD VSS gf180mcu_fd_sc_mcu7t5v0__clkinv_1
X$353 VSS VDD \$346 \$406 VDD VSS gf180mcu_fd_sc_mcu7t5v0__clkinv_1
X$354 VSS VDD \$346 \$355 VDD VSS gf180mcu_fd_sc_mcu7t5v0__clkinv_1
X$355 VSS VDD \$223 \$180 VDD VSS gf180mcu_fd_sc_mcu7t5v0__clkinv_1
X$356 VSS VDD \$12 \$127 VDD VSS gf180mcu_fd_sc_mcu7t5v0__clkinv_1
X$357 VSS VDD \$346 \$425 VDD VSS gf180mcu_fd_sc_mcu7t5v0__clkinv_1
X$358 VSS VDD \$135 \$252 VDD VSS gf180mcu_fd_sc_mcu7t5v0__clkinv_1
X$359 VSS VDD \$135 \$317 VDD VSS gf180mcu_fd_sc_mcu7t5v0__clkinv_1
X$360 VSS VDD \$246 \$231 VDD VSS gf180mcu_fd_sc_mcu7t5v0__clkinv_1
X$361 VSS VDD \$518 \$589 VDD VSS gf180mcu_fd_sc_mcu7t5v0__clkinv_1
X$362 VSS VDD \$495 \$483 VDD VSS gf180mcu_fd_sc_mcu7t5v0__clkinv_1
X$363 VSS VDD \$333 \$503 VDD VSS gf180mcu_fd_sc_mcu7t5v0__clkinv_1
X$364 VSS VDD \$341 \$470 VDD VSS gf180mcu_fd_sc_mcu7t5v0__clkinv_1
X$365 VSS VDD \$135 \$294 VDD VSS gf180mcu_fd_sc_mcu7t5v0__clkinv_1
X$366 VSS VDD \$486 \$548 VDD VSS gf180mcu_fd_sc_mcu7t5v0__clkinv_1
X$367 VSS VDD \$12 \$42 VDD VSS gf180mcu_fd_sc_mcu7t5v0__clkinv_1
X$368 VSS VDD \$183 \$196 VDD VSS gf180mcu_fd_sc_mcu7t5v0__clkinv_1
X$369 VSS VDD \$299 \$418 VDD VSS gf180mcu_fd_sc_mcu7t5v0__clkinv_1
X$370 VSS VDD \$352 \$409 VDD VSS gf180mcu_fd_sc_mcu7t5v0__clkinv_1
X$371 VSS VDD \$171 \$145 VDD VSS gf180mcu_fd_sc_mcu7t5v0__clkinv_1
X$372 VSS VDD \$10 \$124 VDD VSS gf180mcu_fd_sc_mcu7t5v0__clkinv_1
X$373 VSS VDD \$223 \$233 VDD VSS gf180mcu_fd_sc_mcu7t5v0__clkinv_1
X$374 VSS VDD \$284 \$301 VDD VSS gf180mcu_fd_sc_mcu7t5v0__clkinv_1
X$375 VSS VDD \$234 \$173 VDD VSS gf180mcu_fd_sc_mcu7t5v0__clkinv_1
X$376 VSS VDD \$258 \$268 VDD VSS gf180mcu_fd_sc_mcu7t5v0__clkinv_1
X$377 VSS VDD \$258 \$303 VDD VSS gf180mcu_fd_sc_mcu7t5v0__clkinv_1
X$378 VSS VDD \$135 \$255 VDD VSS gf180mcu_fd_sc_mcu7t5v0__clkinv_1
X$379 VSS VDD \$487 \$522 VDD VSS gf180mcu_fd_sc_mcu7t5v0__clkinv_1
X$380 VSS VDD \$10 \$39 VDD VSS gf180mcu_fd_sc_mcu7t5v0__clkinv_1
X$381 VSS VDD \$495 \$583 VDD VSS gf180mcu_fd_sc_mcu7t5v0__clkinv_1
X$382 VSS VDD \$380 \$508 VDD VSS gf180mcu_fd_sc_mcu7t5v0__clkinv_1
X$383 VSS VDD \$602 \$592 VDD VSS gf180mcu_fd_sc_mcu7t5v0__clkinv_1
X$384 VSS VDD \$12 \$41 VDD VSS gf180mcu_fd_sc_mcu7t5v0__clkinv_1
X$385 VSS VDD \$419 \$445 VDD VSS gf180mcu_fd_sc_mcu7t5v0__clkinv_1
X$386 VSS VDD \$405 \$382 VDD VSS gf180mcu_fd_sc_mcu7t5v0__clkinv_1
X$387 VSS VDD \$424 \$383 VDD VSS gf180mcu_fd_sc_mcu7t5v0__clkinv_1
X$388 VSS VDD \$586 \$568 VDD VSS gf180mcu_fd_sc_mcu7t5v0__clkinv_1
X$389 VSS VDD \$322 \$190 VDD VSS gf180mcu_fd_sc_mcu7t5v0__clkinv_1
X$390 VSS VDD \$128 \$126 VDD VSS gf180mcu_fd_sc_mcu7t5v0__clkinv_1
X$391 VSS VDD \$71 \$87 VDD VSS gf180mcu_fd_sc_mcu7t5v0__clkinv_1
X$392 VSS VDD \$352 \$263 VDD VSS gf180mcu_fd_sc_mcu7t5v0__clkinv_1
X$393 VSS VDD \$352 \$378 VDD VSS gf180mcu_fd_sc_mcu7t5v0__clkinv_1
X$394 VSS VDD \$91 \$118 VDD VSS gf180mcu_fd_sc_mcu7t5v0__clkinv_1
X$395 VSS VDD \$70 \$69 VDD VSS gf180mcu_fd_sc_mcu7t5v0__clkinv_1
X$396 VSS VDD \$487 \$498 VDD VSS gf180mcu_fd_sc_mcu7t5v0__clkinv_1
X$397 VSS VDD \$315 \$295 VDD VSS gf180mcu_fd_sc_mcu7t5v0__clkinv_1
X$398 VSS VDD \$495 \$563 VDD VSS gf180mcu_fd_sc_mcu7t5v0__clkinv_1
X$399 VSS VDD \$487 \$566 VDD VSS gf180mcu_fd_sc_mcu7t5v0__clkinv_1
X$400 VSS VDD \$512 \$584 VDD VSS gf180mcu_fd_sc_mcu7t5v0__clkinv_1
X$401 VSS VDD \$352 \$449 VDD VSS gf180mcu_fd_sc_mcu7t5v0__clkinv_1
X$402 VSS VDD \$475 \$436 VDD VSS gf180mcu_fd_sc_mcu7t5v0__clkinv_1
X$403 VSS VDD \$341 \$403 VDD VSS gf180mcu_fd_sc_mcu7t5v0__clkinv_1
X$404 VSS VDD \$379 \$339 VDD VSS gf180mcu_fd_sc_mcu7t5v0__clkinv_1
X$405 VSS VDD \$265 \$240 VDD VSS gf180mcu_fd_sc_mcu7t5v0__clkinv_1
X$406 VSS VDD \$487 \$595 VDD VSS gf180mcu_fd_sc_mcu7t5v0__clkinv_1
X$407 VSS VDD \$495 \$601 VDD VSS gf180mcu_fd_sc_mcu7t5v0__clkinv_1
X$408 VSS VDD \$335 \$377 VDD VSS gf180mcu_fd_sc_mcu7t5v0__clkinv_1
X$409 VSS VDD \$169 \$214 VDD VSS gf180mcu_fd_sc_mcu7t5v0__clkinv_1
X$410 VSS VDD \$169 \$310 VDD VSS gf180mcu_fd_sc_mcu7t5v0__clkinv_1
X$411 VSS VDD \$169 \$202 VDD VSS gf180mcu_fd_sc_mcu7t5v0__clkinv_1
X$412 VSS VDD \$335 \$429 VDD VSS gf180mcu_fd_sc_mcu7t5v0__clkinv_1
X$413 VSS VDD \$335 \$439 VDD VSS gf180mcu_fd_sc_mcu7t5v0__clkinv_1
X$414 VSS VDD \$484 \$579 VDD VSS gf180mcu_fd_sc_mcu7t5v0__clkinv_1
X$415 VSS VDD \$543 \$578 VDD VSS gf180mcu_fd_sc_mcu7t5v0__clkinv_1
X$416 VSS VDD \$169 \$178 VDD VSS gf180mcu_fd_sc_mcu7t5v0__clkinv_1
X$417 VSS VDD \$335 \$351 VDD VSS gf180mcu_fd_sc_mcu7t5v0__clkinv_1
X$418 VSS VDD \$12 \$21 VDD VSS gf180mcu_fd_sc_mcu7t5v0__clkinv_1
X$419 VSS VDD \$341 \$420 VDD VSS gf180mcu_fd_sc_mcu7t5v0__clkinv_1
X$420 VSS VDD \$524 \$534 VDD VSS gf180mcu_fd_sc_mcu7t5v0__clkinv_1
X$421 VSS VDD \$341 \$326 VDD VSS gf180mcu_fd_sc_mcu7t5v0__clkinv_1
X$422 VSS VDD \$184 \$209 VDD VSS gf180mcu_fd_sc_mcu7t5v0__clkinv_1
X$423 VSS VDD \$437 \$463 VDD VSS gf180mcu_fd_sc_mcu7t5v0__clkinv_1
X$424 VSS VDD \$341 \$456 VDD VSS gf180mcu_fd_sc_mcu7t5v0__clkinv_1
X$425 VSS VDD \$602 \$597 VDD VSS gf180mcu_fd_sc_mcu7t5v0__clkinv_1
X$426 VSS VDD \$487 \$535 VDD VSS gf180mcu_fd_sc_mcu7t5v0__clkinv_1
X$427 VSS VDD \$10 \$20 VDD VSS gf180mcu_fd_sc_mcu7t5v0__clkinv_1
X$428 VSS VDD \$12 \$22 VDD VSS gf180mcu_fd_sc_mcu7t5v0__clkinv_1
X$429 VSS VDD \$495 \$544 VDD VSS gf180mcu_fd_sc_mcu7t5v0__clkinv_1
X$430 VSS VDD VDD VSS gf180mcu_fd_sc_mcu7t5v0__fillcap_16
X$431 VSS VDD VDD VSS gf180mcu_fd_sc_mcu7t5v0__fillcap_16
X$432 VSS VDD VDD VSS gf180mcu_fd_sc_mcu7t5v0__fillcap_16
X$433 VSS VDD VDD VSS gf180mcu_fd_sc_mcu7t5v0__fillcap_16
X$434 VSS VDD VDD VSS gf180mcu_fd_sc_mcu7t5v0__fillcap_16
X$435 VSS VDD VDD VSS gf180mcu_fd_sc_mcu7t5v0__fillcap_16
X$436 VSS VDD VDD VSS gf180mcu_fd_sc_mcu7t5v0__fillcap_16
X$437 VSS VDD VDD VSS gf180mcu_fd_sc_mcu7t5v0__fillcap_16
X$438 VSS VDD VDD VSS gf180mcu_fd_sc_mcu7t5v0__fillcap_16
X$439 VSS VDD VDD VSS gf180mcu_fd_sc_mcu7t5v0__fillcap_16
X$440 VSS VDD VDD VSS gf180mcu_fd_sc_mcu7t5v0__fillcap_16
X$441 VSS VDD VDD VSS gf180mcu_fd_sc_mcu7t5v0__fillcap_16
X$442 VSS VDD VDD VSS gf180mcu_fd_sc_mcu7t5v0__fillcap_16
X$443 VSS VDD VDD VSS gf180mcu_fd_sc_mcu7t5v0__fillcap_16
X$444 VSS VDD VDD VSS gf180mcu_fd_sc_mcu7t5v0__fillcap_16
X$445 VSS VDD VDD VSS gf180mcu_fd_sc_mcu7t5v0__fillcap_16
X$446 VSS VDD VDD VSS gf180mcu_fd_sc_mcu7t5v0__fillcap_16
X$447 VSS VDD VDD VSS gf180mcu_fd_sc_mcu7t5v0__fillcap_16
X$448 VSS VDD VDD VSS gf180mcu_fd_sc_mcu7t5v0__fillcap_16
X$449 VSS VDD VDD VSS gf180mcu_fd_sc_mcu7t5v0__fillcap_16
X$450 VSS VDD VDD VSS gf180mcu_fd_sc_mcu7t5v0__fillcap_16
X$524 VDD \$72 VSS \$56 \$55 VDD VSS gf180mcu_fd_sc_mcu7t5v0__xnor2_1
X$532 VSS VDD \$441 \$440 \$392 \$442 \$435 \$436 VDD VSS
+ gf180mcu_fd_sc_mcu7t5v0__oai32_1
X$551 VSS VDD VDD VSS gf180mcu_fd_sc_mcu7t5v0__fillcap_32
X$568 VSS \$301 VDD \$380 \$381 \$361 \$363 \$382 VDD VSS
+ gf180mcu_fd_sc_mcu7t5v0__aoi221_1
X$596 \$206 VDD VSS \$23 VDD VSS gf180mcu_fd_sc_mcu7t5v0__dlyb_1
X$597 \$402 VDD VSS \$264 VDD VSS gf180mcu_fd_sc_mcu7t5v0__dlyb_1
X$598 \$333 VDD VSS \$341 VDD VSS gf180mcu_fd_sc_mcu7t5v0__dlyb_1
X$599 \$189 VDD VSS \$533 VDD VSS gf180mcu_fd_sc_mcu7t5v0__dlyb_1
X$600 \$560 VDD VSS \$570 VDD VSS gf180mcu_fd_sc_mcu7t5v0__dlyb_1
X$601 VDD \$474 \$548 \$513 \$531 VSS \$540 VDD VSS
+ gf180mcu_fd_sc_mcu7t5v0__and4_1
X$602 \$333 VDD VSS \$487 VDD VSS gf180mcu_fd_sc_mcu7t5v0__dlyb_1
X$603 \$519 VDD VSS trigger_out VDD VSS gf180mcu_fd_sc_mcu7t5v0__dlyb_1
X$604 \$299 VDD VSS \$335 VDD VSS gf180mcu_fd_sc_mcu7t5v0__dlyb_1
X$605 \$560 VDD VSS sda_oe VDD VSS gf180mcu_fd_sc_mcu7t5v0__dlyb_1
X$606 \$151 VDD VSS \$236 VDD VSS gf180mcu_fd_sc_mcu7t5v0__dlyb_1
X$607 \$518 VDD VSS sda_out VDD VSS gf180mcu_fd_sc_mcu7t5v0__dlyb_1
X$608 \$79 VDD VSS \$336 VDD VSS gf180mcu_fd_sc_mcu7t5v0__dlyb_1
X$609 \$562 VDD VSS \$560 VDD VSS gf180mcu_fd_sc_mcu7t5v0__dlyb_1
X$610 \$239 VDD VSS \$90 VDD VSS gf180mcu_fd_sc_mcu7t5v0__dlyb_1
X$611 \$151 VDD VSS \$106 VDD VSS gf180mcu_fd_sc_mcu7t5v0__dlyb_1
X$612 \$90 VDD VSS \$205 VDD VSS gf180mcu_fd_sc_mcu7t5v0__dlyb_1
X$613 en VDD VSS \$26 VDD VSS gf180mcu_fd_sc_mcu7t5v0__dlyb_1
X$614 \$206 VDD VSS \$286 VDD VSS gf180mcu_fd_sc_mcu7t5v0__dlyb_1
X$615 \$282 VDD VSS \$44 VDD VSS gf180mcu_fd_sc_mcu7t5v0__dlyb_1
X$616 VSS VDD \$72 \$69 \$73 VDD VSS gf180mcu_fd_sc_mcu7t5v0__nand2_1
X$617 \$335 VDD VSS \$352 VDD VSS gf180mcu_fd_sc_mcu7t5v0__dlyb_1
X$618 \$286 VDD VSS \$468 VDD VSS gf180mcu_fd_sc_mcu7t5v0__dlyb_1
X$619 \$159 VDD VSS \$206 VDD VSS gf180mcu_fd_sc_mcu7t5v0__dlyb_1
X$620 \$26 VDD VSS \$79 VDD VSS gf180mcu_fd_sc_mcu7t5v0__dlyb_1
X$621 \$90 VDD VSS \$52 VDD VSS gf180mcu_fd_sc_mcu7t5v0__dlyb_1
X$622 \$97 VDD VSS \$35 VDD VSS gf180mcu_fd_sc_mcu7t5v0__dlyb_1
X$623 \$90 VDD VSS \$117 VDD VSS gf180mcu_fd_sc_mcu7t5v0__dlyb_1
X$624 \$38 VDD VSS \$27 VDD VSS gf180mcu_fd_sc_mcu7t5v0__dlyb_1
X$625 \$90 VDD VSS \$191 VDD VSS gf180mcu_fd_sc_mcu7t5v0__dlyb_1
X$626 \$431 VDD VSS \$13 VDD VSS gf180mcu_fd_sc_mcu7t5v0__dlyb_1
X$627 \$282 VDD VSS \$360 VDD VSS gf180mcu_fd_sc_mcu7t5v0__dlyb_1
X$628 \$321 VDD VSS \$332 VDD VSS gf180mcu_fd_sc_mcu7t5v0__dlyb_1
X$629 \$256 VDD VSS \$321 VDD VSS gf180mcu_fd_sc_mcu7t5v0__dlyb_1
X$630 VSS clk \$105 VDD VDD VSS gf180mcu_fd_sc_mcu7t5v0__clkbuf_16
X$631 \$264 VDD VSS \$103 VDD VSS gf180mcu_fd_sc_mcu7t5v0__dlyb_1
X$632 \$334 VDD VSS \$375 VDD VSS gf180mcu_fd_sc_mcu7t5v0__dlyb_1
X$633 \$264 VDD VSS \$203 VDD VSS gf180mcu_fd_sc_mcu7t5v0__dlyb_1
X$634 \$27 VDD VSS \$169 VDD VSS gf180mcu_fd_sc_mcu7t5v0__dlyb_1
X$635 \$27 VDD VSS \$223 VDD VSS gf180mcu_fd_sc_mcu7t5v0__dlyb_1
X$636 \$336 VDD VSS \$333 VDD VSS gf180mcu_fd_sc_mcu7t5v0__dlyb_1
X$637 VSS VDD \$301 \$380 \$374 \$365 \$324 \$397 \$295 VDD VSS
+ gf180mcu_fd_sc_mcu7t5v0__oai222_1
X$638 \$333 VDD VSS \$346 VDD VSS gf180mcu_fd_sc_mcu7t5v0__dlyb_1
X$639 \$375 VDD VSS \$386 VDD VSS gf180mcu_fd_sc_mcu7t5v0__dlyb_1
X$640 \$189 VDD VSS \$486 VDD VSS gf180mcu_fd_sc_mcu7t5v0__dlyb_1
X$641 scl VDD VSS \$188 VDD VSS gf180mcu_fd_sc_mcu7t5v0__dlyb_1
X$642 \$336 VDD VSS \$299 VDD VSS gf180mcu_fd_sc_mcu7t5v0__dlyb_1
X$643 \$275 VDD VSS \$256 VDD VSS gf180mcu_fd_sc_mcu7t5v0__dlyb_1
X$644 sda_in VDD VSS \$358 VDD VSS gf180mcu_fd_sc_mcu7t5v0__dlyb_1
X$645 \$299 VDD VSS \$495 VDD VSS gf180mcu_fd_sc_mcu7t5v0__dlyb_1
X$646 \$299 VDD VSS \$602 VDD VSS gf180mcu_fd_sc_mcu7t5v0__dlyb_1
X$647 VSS VDD VDD VSS gf180mcu_fd_sc_mcu7t5v0__fillcap_64
X$648 \$79 VDD VSS \$38 VDD VSS gf180mcu_fd_sc_mcu7t5v0__dlyb_1
X$649 \$206 VDD VSS \$218 VDD VSS gf180mcu_fd_sc_mcu7t5v0__dlyb_1
X$650 \$431 VDD VSS \$251 VDD VSS gf180mcu_fd_sc_mcu7t5v0__dlyb_1
X$651 VSS VDD \$13 \$24 \$23 \$55 VDD VSS gf180mcu_fd_sc_mcu7t5v0__nor3_1
X$899 VSS VDD \$117 \$44 \$28 VDD VSS gf180mcu_fd_sc_mcu7t5v0__nor2_1
X$948 \$543 VSS \$454 \$462 VDD \$531 VDD VSS gf180mcu_fd_sc_mcu7t5v0__or3_1
X$953 VSS VDD VDD VSS gf180mcu_fd_sc_mcu7t5v0__fillcap_4
X$954 VSS VDD VDD VSS gf180mcu_fd_sc_mcu7t5v0__fillcap_4
X$955 VSS VDD VDD VSS gf180mcu_fd_sc_mcu7t5v0__fillcap_4
X$956 VSS VDD VDD VSS gf180mcu_fd_sc_mcu7t5v0__fillcap_4
X$957 VSS VDD VDD VSS gf180mcu_fd_sc_mcu7t5v0__fillcap_4
X$958 VSS VDD VDD VSS gf180mcu_fd_sc_mcu7t5v0__fillcap_4
X$959 VSS VDD VDD VSS gf180mcu_fd_sc_mcu7t5v0__fillcap_4
X$960 VSS VDD VDD VSS gf180mcu_fd_sc_mcu7t5v0__fillcap_4
X$961 VSS VDD VDD VSS gf180mcu_fd_sc_mcu7t5v0__fillcap_4
X$962 VSS VDD VDD VSS gf180mcu_fd_sc_mcu7t5v0__fillcap_4
X$963 VSS VDD VDD VSS gf180mcu_fd_sc_mcu7t5v0__fillcap_4
X$964 VSS VDD VDD VSS gf180mcu_fd_sc_mcu7t5v0__fillcap_4
X$965 VSS VDD VDD VSS gf180mcu_fd_sc_mcu7t5v0__fillcap_4
X$966 VSS VDD VDD VSS gf180mcu_fd_sc_mcu7t5v0__fillcap_4
X$967 VSS VDD VDD VSS gf180mcu_fd_sc_mcu7t5v0__fillcap_4
X$968 VSS VDD VDD VSS gf180mcu_fd_sc_mcu7t5v0__fillcap_4
X$969 VSS VDD VDD VSS gf180mcu_fd_sc_mcu7t5v0__fillcap_4
X$970 VSS VDD VDD VSS gf180mcu_fd_sc_mcu7t5v0__fillcap_4
X$971 VSS VDD VDD VSS gf180mcu_fd_sc_mcu7t5v0__fillcap_4
X$972 VSS VDD VDD VSS gf180mcu_fd_sc_mcu7t5v0__fillcap_4
X$973 VSS VDD VDD VSS gf180mcu_fd_sc_mcu7t5v0__fillcap_4
X$974 VSS VDD \$37 \$11 \$36 \$35 VDD VSS gf180mcu_fd_sc_mcu7t5v0__mux2_2
X$975 VSS VDD VDD VSS gf180mcu_fd_sc_mcu7t5v0__fillcap_4
X$976 VSS VDD VDD VSS gf180mcu_fd_sc_mcu7t5v0__fillcap_4
X$977 VSS VDD VDD VSS gf180mcu_fd_sc_mcu7t5v0__fillcap_4
X$978 VSS VDD VDD VSS gf180mcu_fd_sc_mcu7t5v0__fillcap_4
X$979 VSS VDD VDD VSS gf180mcu_fd_sc_mcu7t5v0__fillcap_4
X$980 VSS VDD VDD VSS gf180mcu_fd_sc_mcu7t5v0__fillcap_4
X$981 VSS VDD VDD VSS gf180mcu_fd_sc_mcu7t5v0__fillcap_4
X$982 VSS VDD VDD VSS gf180mcu_fd_sc_mcu7t5v0__fillcap_4
X$983 VSS VDD VDD VSS gf180mcu_fd_sc_mcu7t5v0__fillcap_4
X$984 VSS VDD VDD VSS gf180mcu_fd_sc_mcu7t5v0__fillcap_4
X$985 VSS VDD VDD VSS gf180mcu_fd_sc_mcu7t5v0__fillcap_4
X$986 VSS VDD VDD VSS gf180mcu_fd_sc_mcu7t5v0__fillcap_4
X$987 VSS VDD VDD VSS gf180mcu_fd_sc_mcu7t5v0__fillcap_4
X$988 VSS VDD VDD VSS gf180mcu_fd_sc_mcu7t5v0__fillcap_4
X$989 VSS VDD VDD VSS gf180mcu_fd_sc_mcu7t5v0__fillcap_4
X$990 VSS VDD VDD VSS gf180mcu_fd_sc_mcu7t5v0__fillcap_4
X$991 VSS VDD VDD VSS gf180mcu_fd_sc_mcu7t5v0__fillcap_4
X$992 VSS VDD VDD VSS gf180mcu_fd_sc_mcu7t5v0__fillcap_4
X$993 VSS VDD VDD VSS gf180mcu_fd_sc_mcu7t5v0__fillcap_4
X$994 VSS VDD VDD VSS gf180mcu_fd_sc_mcu7t5v0__fillcap_4
X$995 VSS VDD VDD VSS gf180mcu_fd_sc_mcu7t5v0__fillcap_4
X$996 VSS VDD VDD VSS gf180mcu_fd_sc_mcu7t5v0__fillcap_4
X$997 VSS VDD VDD VSS gf180mcu_fd_sc_mcu7t5v0__fillcap_4
X$998 VSS VDD VDD VSS gf180mcu_fd_sc_mcu7t5v0__fillcap_4
X$999 VSS VDD VDD VSS gf180mcu_fd_sc_mcu7t5v0__fillcap_4
X$1000 VSS VDD VDD VSS gf180mcu_fd_sc_mcu7t5v0__fillcap_4
X$1001 VSS VDD VDD VSS gf180mcu_fd_sc_mcu7t5v0__fillcap_4
X$1002 VSS VDD VDD VSS gf180mcu_fd_sc_mcu7t5v0__fillcap_4
X$1003 VSS VDD VDD VSS gf180mcu_fd_sc_mcu7t5v0__fillcap_4
X$1004 VSS VDD VDD VSS gf180mcu_fd_sc_mcu7t5v0__fillcap_4
X$1005 VSS VDD VDD VSS gf180mcu_fd_sc_mcu7t5v0__fillcap_4
X$1006 VSS VDD VDD VSS gf180mcu_fd_sc_mcu7t5v0__fillcap_4
X$1007 VSS VDD VDD VSS gf180mcu_fd_sc_mcu7t5v0__fillcap_4
X$1008 VSS VDD VDD VSS gf180mcu_fd_sc_mcu7t5v0__fillcap_4
X$1009 VSS VDD VDD VSS gf180mcu_fd_sc_mcu7t5v0__fillcap_4
X$1010 VSS VDD VDD VSS gf180mcu_fd_sc_mcu7t5v0__fillcap_4
X$1011 VSS VDD VDD VSS gf180mcu_fd_sc_mcu7t5v0__fillcap_4
X$1012 VSS VDD VDD VSS gf180mcu_fd_sc_mcu7t5v0__fillcap_4
X$1013 VSS VDD VDD VSS gf180mcu_fd_sc_mcu7t5v0__fillcap_4
X$1014 VSS VDD VDD VSS gf180mcu_fd_sc_mcu7t5v0__fillcap_4
X$1015 VSS VDD VDD VSS gf180mcu_fd_sc_mcu7t5v0__fillcap_4
X$1016 VSS VDD VDD VSS gf180mcu_fd_sc_mcu7t5v0__fillcap_4
X$1017 VSS VDD VDD VSS gf180mcu_fd_sc_mcu7t5v0__fillcap_4
X$1018 VSS VDD VDD VSS gf180mcu_fd_sc_mcu7t5v0__fillcap_4
X$1019 VSS VDD VDD VSS gf180mcu_fd_sc_mcu7t5v0__fillcap_4
X$1020 VSS VDD VDD VSS gf180mcu_fd_sc_mcu7t5v0__fillcap_4
X$1021 VSS VDD VDD VSS gf180mcu_fd_sc_mcu7t5v0__fillcap_4
X$1022 VSS VDD VDD VSS gf180mcu_fd_sc_mcu7t5v0__fillcap_4
X$1023 VSS VDD VDD VSS gf180mcu_fd_sc_mcu7t5v0__fillcap_4
X$1024 VSS VDD VDD VSS gf180mcu_fd_sc_mcu7t5v0__fillcap_4
X$1025 VSS VDD VDD VSS gf180mcu_fd_sc_mcu7t5v0__fillcap_4
X$1026 VSS VDD VDD VSS gf180mcu_fd_sc_mcu7t5v0__fillcap_4
X$1027 VSS VDD VDD VSS gf180mcu_fd_sc_mcu7t5v0__fillcap_4
X$1028 VSS VDD VDD VSS gf180mcu_fd_sc_mcu7t5v0__fillcap_4
X$1029 VSS VDD VDD VSS gf180mcu_fd_sc_mcu7t5v0__fillcap_4
X$1030 VSS VDD VDD VSS gf180mcu_fd_sc_mcu7t5v0__fillcap_4
X$1031 VSS VDD VDD VSS gf180mcu_fd_sc_mcu7t5v0__fillcap_4
X$1032 VSS VDD VDD VSS gf180mcu_fd_sc_mcu7t5v0__fillcap_4
X$1033 VSS VDD VDD VSS gf180mcu_fd_sc_mcu7t5v0__fillcap_4
X$1034 VSS VDD VDD VSS gf180mcu_fd_sc_mcu7t5v0__fillcap_4
X$1035 VSS VDD VDD VSS gf180mcu_fd_sc_mcu7t5v0__fillcap_4
X$1036 VSS VDD VDD VSS gf180mcu_fd_sc_mcu7t5v0__fillcap_4
X$1037 VSS VDD VDD VSS gf180mcu_fd_sc_mcu7t5v0__fillcap_4
X$1038 VSS VDD VDD VSS gf180mcu_fd_sc_mcu7t5v0__fillcap_4
X$1039 VSS VDD VDD VSS gf180mcu_fd_sc_mcu7t5v0__fillcap_4
X$1040 VSS VDD VDD VSS gf180mcu_fd_sc_mcu7t5v0__fillcap_4
X$1041 VSS VDD VDD VSS gf180mcu_fd_sc_mcu7t5v0__fillcap_4
X$1042 VSS VDD VDD VSS gf180mcu_fd_sc_mcu7t5v0__fillcap_4
X$1043 VSS VDD VDD VSS gf180mcu_fd_sc_mcu7t5v0__fillcap_4
X$1044 VSS VDD VDD VSS gf180mcu_fd_sc_mcu7t5v0__fillcap_4
X$1045 VSS VDD VDD VSS gf180mcu_fd_sc_mcu7t5v0__fillcap_4
X$1046 VSS VDD VDD VSS gf180mcu_fd_sc_mcu7t5v0__fillcap_4
X$1047 VSS VDD VDD VSS gf180mcu_fd_sc_mcu7t5v0__fillcap_4
X$1048 VSS VDD VDD VSS gf180mcu_fd_sc_mcu7t5v0__fillcap_4
X$1049 VSS VDD VDD VSS gf180mcu_fd_sc_mcu7t5v0__fillcap_4
X$1050 VSS VDD VDD VSS gf180mcu_fd_sc_mcu7t5v0__fillcap_4
X$1051 VSS VDD VDD VSS gf180mcu_fd_sc_mcu7t5v0__fillcap_4
X$1052 VSS VDD VDD VSS gf180mcu_fd_sc_mcu7t5v0__fillcap_4
X$1053 VSS VDD VDD VSS gf180mcu_fd_sc_mcu7t5v0__fillcap_4
X$1054 VSS VDD VDD VSS gf180mcu_fd_sc_mcu7t5v0__fillcap_4
X$1055 VSS VDD VDD VSS gf180mcu_fd_sc_mcu7t5v0__fillcap_4
X$1056 VSS VDD VDD VSS gf180mcu_fd_sc_mcu7t5v0__fillcap_4
X$1057 VSS VDD VDD VSS gf180mcu_fd_sc_mcu7t5v0__fillcap_4
X$1058 VSS VDD VDD VSS gf180mcu_fd_sc_mcu7t5v0__fillcap_4
X$1059 VSS VDD VDD VSS gf180mcu_fd_sc_mcu7t5v0__fillcap_8
X$1060 VSS VDD VDD VSS gf180mcu_fd_sc_mcu7t5v0__fillcap_8
X$1061 VSS VDD VDD VSS gf180mcu_fd_sc_mcu7t5v0__fillcap_8
X$1062 VSS VDD VDD VSS gf180mcu_fd_sc_mcu7t5v0__fillcap_8
X$1063 VSS VDD VDD VSS gf180mcu_fd_sc_mcu7t5v0__fillcap_8
X$1064 VSS VDD VDD VSS gf180mcu_fd_sc_mcu7t5v0__fillcap_8
X$1065 VSS VDD VDD VSS gf180mcu_fd_sc_mcu7t5v0__fillcap_8
X$1066 VSS VDD VDD VSS gf180mcu_fd_sc_mcu7t5v0__fillcap_8
X$1067 VSS VDD VDD VSS gf180mcu_fd_sc_mcu7t5v0__fillcap_8
X$1068 VSS VDD VDD VSS gf180mcu_fd_sc_mcu7t5v0__fillcap_8
X$1069 VSS VDD VDD VSS gf180mcu_fd_sc_mcu7t5v0__fillcap_8
X$1070 VSS VDD VDD VSS gf180mcu_fd_sc_mcu7t5v0__fillcap_8
X$1071 VSS VDD VDD VSS gf180mcu_fd_sc_mcu7t5v0__fillcap_8
X$1072 VSS VDD VDD VSS gf180mcu_fd_sc_mcu7t5v0__fillcap_8
X$1073 VSS VDD VDD VSS gf180mcu_fd_sc_mcu7t5v0__fillcap_8
X$1074 VSS VDD VDD VSS gf180mcu_fd_sc_mcu7t5v0__fillcap_8
X$1075 VSS VDD VDD VSS gf180mcu_fd_sc_mcu7t5v0__fillcap_8
X$1076 VSS VDD VDD VSS gf180mcu_fd_sc_mcu7t5v0__fillcap_8
X$1077 VSS VDD VDD VSS gf180mcu_fd_sc_mcu7t5v0__fillcap_8
X$1078 VSS VDD VDD VSS gf180mcu_fd_sc_mcu7t5v0__fillcap_8
X$1079 VSS VDD VDD VSS gf180mcu_fd_sc_mcu7t5v0__fillcap_8
X$1080 VSS VDD VDD VSS gf180mcu_fd_sc_mcu7t5v0__fillcap_8
X$1081 VSS VDD VDD VSS gf180mcu_fd_sc_mcu7t5v0__fillcap_8
X$1082 VSS VDD VDD VSS gf180mcu_fd_sc_mcu7t5v0__fillcap_8
X$1083 VSS VDD VDD VSS gf180mcu_fd_sc_mcu7t5v0__fillcap_8
X$1084 VSS VDD VDD VSS gf180mcu_fd_sc_mcu7t5v0__fillcap_8
X$1085 VSS VDD VDD VSS gf180mcu_fd_sc_mcu7t5v0__fillcap_8
X$1086 VSS VDD VDD VSS gf180mcu_fd_sc_mcu7t5v0__fillcap_8
X$1087 VSS VDD VDD VSS gf180mcu_fd_sc_mcu7t5v0__fillcap_8
X$1088 VSS VDD VDD VSS gf180mcu_fd_sc_mcu7t5v0__fillcap_8
X$1089 VSS VDD VDD VSS gf180mcu_fd_sc_mcu7t5v0__fillcap_8
X$1090 VSS VDD VDD VSS gf180mcu_fd_sc_mcu7t5v0__fillcap_8
X$1091 VSS VDD VDD VSS gf180mcu_fd_sc_mcu7t5v0__fillcap_8
X$1092 VSS VDD VDD VSS gf180mcu_fd_sc_mcu7t5v0__fillcap_8
X$1093 VSS VDD VDD VSS gf180mcu_fd_sc_mcu7t5v0__fillcap_8
X$1094 VSS VDD VDD VSS gf180mcu_fd_sc_mcu7t5v0__fillcap_8
X$1095 VSS VDD VDD VSS gf180mcu_fd_sc_mcu7t5v0__fillcap_8
X$1096 VSS VDD VDD VSS gf180mcu_fd_sc_mcu7t5v0__fillcap_8
X$1097 VSS VDD VDD VSS gf180mcu_fd_sc_mcu7t5v0__fillcap_8
X$1098 VSS VDD VDD VSS gf180mcu_fd_sc_mcu7t5v0__fillcap_8
X$1099 VSS VDD VDD VSS gf180mcu_fd_sc_mcu7t5v0__fillcap_8
X$1100 VSS VDD VDD VSS gf180mcu_fd_sc_mcu7t5v0__fillcap_8
X$1101 VSS VDD VDD VSS gf180mcu_fd_sc_mcu7t5v0__fillcap_8
X$1102 VSS VDD VDD VSS gf180mcu_fd_sc_mcu7t5v0__fillcap_8
X$1103 VSS VDD VDD VSS gf180mcu_fd_sc_mcu7t5v0__fillcap_8
X$1104 VSS VDD VDD VSS gf180mcu_fd_sc_mcu7t5v0__fillcap_8
X$1105 VSS VDD VDD VSS gf180mcu_fd_sc_mcu7t5v0__fillcap_8
X$1106 VSS VDD VDD VSS gf180mcu_fd_sc_mcu7t5v0__fillcap_8
X$1107 VSS VDD VDD VSS gf180mcu_fd_sc_mcu7t5v0__fillcap_8
X$1108 VSS VDD VDD VSS gf180mcu_fd_sc_mcu7t5v0__fillcap_8
X$1109 VSS VDD VDD VSS gf180mcu_fd_sc_mcu7t5v0__fillcap_8
X$1110 VSS VDD VDD VSS gf180mcu_fd_sc_mcu7t5v0__fillcap_8
X$1111 VSS VDD VDD VSS gf180mcu_fd_sc_mcu7t5v0__fillcap_8
X$1112 VSS VDD VDD VSS gf180mcu_fd_sc_mcu7t5v0__fillcap_8
X$1113 VSS VDD VDD VSS gf180mcu_fd_sc_mcu7t5v0__fillcap_8
X$1114 VSS VDD VDD VSS gf180mcu_fd_sc_mcu7t5v0__fillcap_8
X$1115 VSS VDD VDD VSS gf180mcu_fd_sc_mcu7t5v0__fillcap_8
X$1116 VSS VDD VDD VSS gf180mcu_fd_sc_mcu7t5v0__fillcap_8
X$1117 VSS VDD VDD VSS gf180mcu_fd_sc_mcu7t5v0__fillcap_8
X$1119 VSS VDD VDD VSS gf180mcu_fd_sc_mcu7t5v0__fillcap_4
X$1123 VSS VDD VDD VSS gf180mcu_fd_sc_mcu7t5v0__fillcap_16
X$1178 VSS \$189 \$186 \$188 \$178 VDD VDD VSS gf180mcu_fd_sc_mcu7t5v0__dffsnq_1
.ENDS digital_top

.SUBCKT B04_clock_gen En Vout VDD GND
C$1 \$1 GND 4.8e-12 cap_mim_2f0fF A=2400P P=720U
M$13 \$22 VDD \$1 GND nfet_03v3 L=20U W=0.5U AS=0.22P AD=0.22P PS=1.88U PD=1.88U
M$14 \$22 GND \$1 VDD pfet_03v3 L=10U W=0.5U AS=0.22P AD=0.22P PS=1.88U PD=1.88U
M$15 \$20 \$17 VDD VDD pfet_03v3 L=1U W=0.5U AS=0.22P AD=0.22P PS=1.88U PD=1.88U
M$16 \$19 En \$20 \$20 pfet_03v3 L=1U W=0.5U AS=0.22P AD=0.22P PS=1.88U PD=1.88U
M$17 \$22 \$19 VDD VDD pfet_03v3 L=1U W=0.5U AS=0.22P AD=0.22P PS=1.88U PD=1.88U
M$18 Vout \$22 VDD VDD pfet_03v3 L=1U W=0.5U AS=0.22P AD=0.22P PS=1.88U PD=1.88U
M$19 GND \$17 \$19 GND nfet_03v3 L=1U W=0.5U AS=0.22P AD=0.22P PS=1.88U PD=1.88U
M$20 GND En \$19 GND nfet_03v3 L=1U W=0.5U AS=0.22P AD=0.22P PS=1.88U PD=1.88U
M$21 GND \$19 \$22 GND nfet_03v3 L=1U W=0.5U AS=0.22P AD=0.22P PS=1.88U PD=1.88U
M$22 GND \$22 Vout GND nfet_03v3 L=1U W=0.5U AS=0.22P AD=0.22P PS=1.88U PD=1.88U
M$23 VDD \$17 \$I64 GND nfet_03v3 L=1U W=1U AS=0.44P AD=0.44P PS=2.88U PD=2.88U
M$24 GND VDD GND GND nfet_03v3 L=27U W=0.5U AS=0.22P AD=0.22P PS=1.88U PD=1.88U
M$25 GND \$1 \$I64 GND nfet_03v3 L=27U W=0.5U AS=0.22P AD=0.22P PS=1.88U
+ PD=1.88U
M$26 \$17 \$1 \$I64 GND nfet_03v3 L=27U W=0.5U AS=0.22P AD=0.22P PS=1.88U
+ PD=1.88U
M$27 GND \$17 \$I65 VDD pfet_03v3 L=1U W=1U AS=0.44P AD=0.44P PS=2.88U PD=2.88U
M$28 \$I66 \$1 \$I65 VDD pfet_03v3 L=27U W=0.5U AS=0.22P AD=0.22P PS=1.88U
+ PD=1.88U
M$29 \$I66 GND VDD VDD pfet_03v3 L=27U W=0.5U AS=0.22P AD=0.22P PS=1.88U
+ PD=1.88U
M$30 \$17 \$1 \$I65 VDD pfet_03v3 L=27U W=0.5U AS=0.22P AD=0.22P PS=1.88U
+ PD=1.88U
.ENDS B04_clock_gen

.SUBCKT B04_AFE_top Venvelope Vbpf VDD Vin Cap2 Cap1 Cap0 Vthreshold Vout GND
X$101 \$9 \$17 VDD Venvelope \$15 Vbpf \$28 GND B04_buffer_out
X$126 \$17 \$9 VDD GND B04_BMR
X$127 Cap0 Cap1 Cap2 \$9 \$29 \$17 VDD \$28 \$72 GND B04_BPF4
X$132 \$17 \$9 VDD \$29 GND B04_VDD05
X$152 \$15 \$9 VDD \$28 GND B04_envelope
X$153 Vin \$26 VDD \$17 GND B04_LNAv2
X$573 \$17 Vout Vthreshold \$15 VDD GND B04_comparator
X$722 \$26 \$72 \$29 B04_coupling
.ENDS B04_AFE_top

.SUBCKT gf180mcu_fd_sc_mcu7t5v0__oai211_1 VDD A2 A1 ZN B C VSS \$12 SUB
M$1 \$11 A2 VDD \$12 pfet_05v0 L=0.5U W=1.22U AS=0.5978P AD=0.3172P PS=3.42U
+ PD=1.74U
M$2 ZN A1 \$11 \$12 pfet_05v0 L=0.5U W=1.22U AS=0.3172P AD=0.4016P PS=1.74U
+ PD=1.94U
M$3 VDD B ZN \$12 pfet_05v0 L=0.5U W=0.985U AS=0.4016P AD=0.2561P PS=1.94U
+ PD=1.505U
M$4 ZN C VDD \$12 pfet_05v0 L=0.5U W=0.985U AS=0.2561P AD=0.44325P PS=1.505U
+ PD=2.87U
M$5 ZN A2 \$4 SUB nfet_05v0 L=0.6U W=0.82U AS=0.3608P AD=0.2132P PS=2.52U
+ PD=1.34U
M$6 \$4 A1 ZN SUB nfet_05v0 L=0.6U W=0.82U AS=0.2132P AD=0.2132P PS=1.34U
+ PD=1.34U
M$7 \$10 B \$4 SUB nfet_05v0 L=0.6U W=0.82U AS=0.2132P AD=0.2132P PS=1.34U
+ PD=1.34U
M$8 VSS C \$10 SUB nfet_05v0 L=0.6U W=0.82U AS=0.2132P AD=0.3608P PS=1.34U
+ PD=2.52U
.ENDS gf180mcu_fd_sc_mcu7t5v0__oai211_1

.SUBCKT gf180mcu_fd_sc_mcu7t5v0__oai222_1 VSS VDD C2 C1 ZN B1 B2 A2 A1 \$16 SUB
M$1 \$15 C2 VDD \$16 pfet_05v0 L=0.5U W=1.095U AS=0.4818P AD=0.2847P PS=3.07U
+ PD=1.615U
M$2 ZN C1 \$15 \$16 pfet_05v0 L=0.5U W=1.095U AS=0.2847P AD=0.73365P PS=1.615U
+ PD=2.435U
M$3 \$14 B1 ZN \$16 pfet_05v0 L=0.5U W=1.095U AS=0.73365P AD=0.33945P PS=2.435U
+ PD=1.715U
M$4 VDD B2 \$14 \$16 pfet_05v0 L=0.5U W=1.095U AS=0.33945P AD=0.3942P PS=1.715U
+ PD=1.815U
M$5 \$13 A2 VDD \$16 pfet_05v0 L=0.5U W=1.095U AS=0.3942P AD=0.40515P PS=1.815U
+ PD=1.835U
M$6 ZN A1 \$13 \$16 pfet_05v0 L=0.5U W=1.095U AS=0.40515P AD=0.4818P PS=1.835U
+ PD=3.07U
M$7 \$6 A1 ZN SUB nfet_05v0 L=0.6U W=0.82U AS=0.30965P AD=0.3608P PS=1.685U
+ PD=2.52U
M$8 \$4 B1 \$6 SUB nfet_05v0 L=0.6U W=0.82U AS=0.3608P AD=0.2132P PS=2.52U
+ PD=1.34U
M$9 \$6 B2 \$4 SUB nfet_05v0 L=0.6U W=0.82U AS=0.2132P AD=0.2132P PS=1.34U
+ PD=1.34U
M$10 \$6 A2 ZN SUB nfet_05v0 L=0.6U W=0.82U AS=0.30965P AD=0.2132P PS=1.685U
+ PD=1.34U
M$11 \$4 C2 VSS SUB nfet_05v0 L=0.6U W=0.82U AS=0.3608P AD=0.2132P PS=2.52U
+ PD=1.34U
M$12 VSS C1 \$4 SUB nfet_05v0 L=0.6U W=0.82U AS=0.2132P AD=0.3608P PS=1.34U
+ PD=2.52U
.ENDS gf180mcu_fd_sc_mcu7t5v0__oai222_1

.SUBCKT gf180mcu_fd_sc_mcu7t5v0__aoi221_1 VSS B2 VDD B1 C A2 ZN A1 \$14 SUB
M$1 VDD B2 \$2 \$14 pfet_05v0 L=0.5U W=1.215U AS=0.5346P AD=0.3159P PS=3.31U
+ PD=1.735U
M$2 \$2 B1 VDD \$14 pfet_05v0 L=0.5U W=1.215U AS=0.3159P AD=0.37665P PS=1.735U
+ PD=1.835U
M$3 \$7 C \$2 \$14 pfet_05v0 L=0.5U W=1.215U AS=0.37665P AD=0.3402P PS=1.835U
+ PD=1.775U
M$4 ZN A2 \$7 \$14 pfet_05v0 L=0.5U W=1.215U AS=0.3402P AD=0.37665P PS=1.775U
+ PD=1.835U
M$5 \$7 A1 ZN \$14 pfet_05v0 L=0.5U W=1.215U AS=0.37665P AD=0.5346P PS=1.835U
+ PD=3.31U
M$6 VSS C ZN SUB nfet_05v0 L=0.6U W=0.465U AS=0.21175P AD=0.22595P PS=1.41U
+ PD=1.45U
M$7 \$13 B2 VSS SUB nfet_05v0 L=0.6U W=0.71U AS=0.3124P AD=0.0852P PS=2.3U
+ PD=0.95U
M$8 ZN B1 \$13 SUB nfet_05v0 L=0.6U W=0.71U AS=0.0852P AD=0.21175P PS=0.95U
+ PD=1.41U
M$9 \$12 A2 VSS SUB nfet_05v0 L=0.6U W=0.71U AS=0.22595P AD=0.0852P PS=1.45U
+ PD=0.95U
M$10 ZN A1 \$12 SUB nfet_05v0 L=0.6U W=0.71U AS=0.0852P AD=0.3124P PS=0.95U
+ PD=2.3U
.ENDS gf180mcu_fd_sc_mcu7t5v0__aoi221_1

.SUBCKT gf180mcu_fd_sc_mcu7t5v0__oai221_1 VDD B2 VSS B1 ZN C A2 A1 \$14 SUB
M$1 \$13 B2 VDD \$14 pfet_05v0 L=0.5U W=1.22U AS=0.6588P AD=0.3172P PS=3.52U
+ PD=1.74U
M$2 ZN B1 \$13 \$14 pfet_05v0 L=0.5U W=1.22U AS=0.3172P AD=0.3952P PS=1.74U
+ PD=1.94U
M$3 VDD C ZN \$14 pfet_05v0 L=0.5U W=0.945U AS=0.3952P AD=0.38575P PS=1.94U
+ PD=1.92U
M$4 \$12 A2 VDD \$14 pfet_05v0 L=0.5U W=1.22U AS=0.38575P AD=0.3172P PS=1.92U
+ PD=1.74U
M$5 ZN A1 \$12 \$14 pfet_05v0 L=0.5U W=1.22U AS=0.3172P AD=0.5368P PS=1.74U
+ PD=3.32U
M$6 VSS B2 \$1 SUB nfet_05v0 L=0.6U W=0.82U AS=0.3608P AD=0.2132P PS=2.52U
+ PD=1.34U
M$7 \$1 B1 VSS SUB nfet_05v0 L=0.6U W=0.82U AS=0.2132P AD=0.2132P PS=1.34U
+ PD=1.34U
M$8 \$8 C \$1 SUB nfet_05v0 L=0.6U W=0.82U AS=0.2132P AD=0.246P PS=1.34U
+ PD=1.42U
M$9 ZN A2 \$8 SUB nfet_05v0 L=0.6U W=0.82U AS=0.246P AD=0.2132P PS=1.42U
+ PD=1.34U
M$10 \$8 A1 ZN SUB nfet_05v0 L=0.6U W=0.82U AS=0.2132P AD=0.3608P PS=1.34U
+ PD=2.52U
.ENDS gf180mcu_fd_sc_mcu7t5v0__oai221_1

.SUBCKT gf180mcu_fd_sc_mcu7t5v0__and3_1 A1 VDD A2 A3 VSS Z \$11 SUB
M$1 VDD A1 \$6 \$11 pfet_05v0 L=0.5U W=0.535U AS=0.2354P AD=0.1391P PS=1.95U
+ PD=1.055U
M$2 \$6 A2 VDD \$11 pfet_05v0 L=0.5U W=0.535U AS=0.1391P AD=0.1391P PS=1.055U
+ PD=1.055U
M$3 \$6 A3 VDD \$11 pfet_05v0 L=0.5U W=0.535U AS=0.4268P AD=0.1391P PS=2.175U
+ PD=1.055U
M$4 Z \$6 VDD \$11 pfet_05v0 L=0.5U W=1.215U AS=0.4268P AD=0.5346P PS=2.175U
+ PD=3.31U
M$5 \$10 A1 \$6 SUB nfet_05v0 L=0.6U W=0.38U AS=0.1672P AD=0.0608P PS=1.64U
+ PD=0.7U
M$6 \$9 A2 \$10 SUB nfet_05v0 L=0.6U W=0.38U AS=0.0608P AD=0.0798P PS=0.7U
+ PD=0.8U
M$7 \$9 A3 VSS SUB nfet_05v0 L=0.6U W=0.38U AS=0.2424P AD=0.0798P PS=1.635U
+ PD=0.8U
M$8 Z \$6 VSS SUB nfet_05v0 L=0.6U W=0.775U AS=0.2424P AD=0.341P PS=1.635U
+ PD=2.43U
.ENDS gf180mcu_fd_sc_mcu7t5v0__and3_1

.SUBCKT gf180mcu_fd_sc_mcu7t5v0__oai32_1 VSS VDD A3 A2 A1 ZN B1 B2 \$14 SUB
M$1 \$13 A3 VDD \$14 pfet_05v0 L=0.5U W=1.22U AS=0.5368P AD=0.4392P PS=3.32U
+ PD=1.94U
M$2 \$12 A2 \$13 \$14 pfet_05v0 L=0.5U W=1.22U AS=0.4392P AD=0.3172P PS=1.94U
+ PD=1.74U
M$3 ZN A1 \$12 \$14 pfet_05v0 L=0.5U W=1.22U AS=0.3172P AD=0.4392P PS=1.74U
+ PD=1.94U
M$4 \$11 B1 ZN \$14 pfet_05v0 L=0.5U W=1.22U AS=0.4392P AD=0.3172P PS=1.94U
+ PD=1.74U
M$5 VDD B2 \$11 \$14 pfet_05v0 L=0.5U W=1.22U AS=0.3172P AD=0.5368P PS=1.74U
+ PD=3.32U
M$6 \$4 A3 VSS SUB nfet_05v0 L=0.6U W=0.82U AS=0.3608P AD=0.2132P PS=2.52U
+ PD=1.34U
M$7 VSS A2 \$4 SUB nfet_05v0 L=0.6U W=0.82U AS=0.2132P AD=0.2132P PS=1.34U
+ PD=1.34U
M$8 \$4 A1 VSS SUB nfet_05v0 L=0.6U W=0.82U AS=0.2132P AD=0.2132P PS=1.34U
+ PD=1.34U
M$9 ZN B1 \$4 SUB nfet_05v0 L=0.6U W=0.82U AS=0.2132P AD=0.2132P PS=1.34U
+ PD=1.34U
M$10 \$4 B2 ZN SUB nfet_05v0 L=0.6U W=0.82U AS=0.2132P AD=0.3608P PS=1.34U
+ PD=2.52U
.ENDS gf180mcu_fd_sc_mcu7t5v0__oai32_1

.SUBCKT gf180mcu_fd_sc_mcu7t5v0__and4_1 VDD A1 A2 A3 A4 VSS Z \$13 SUB
M$1 \$7 A1 VDD \$13 pfet_05v0 L=0.5U W=0.6U AS=0.264P AD=0.156P PS=2.08U
+ PD=1.12U
M$2 VDD A2 \$7 \$13 pfet_05v0 L=0.5U W=0.6U AS=0.156P AD=0.156P PS=1.12U
+ PD=1.12U
M$3 \$7 A3 VDD \$13 pfet_05v0 L=0.5U W=0.6U AS=0.156P AD=0.156P PS=1.12U
+ PD=1.12U
M$4 \$7 A4 VDD \$13 pfet_05v0 L=0.5U W=0.6U AS=0.395P AD=0.156P PS=2.02U
+ PD=1.12U
M$5 Z \$7 VDD \$13 pfet_05v0 L=0.5U W=1.22U AS=0.395P AD=0.5368P PS=2.02U
+ PD=3.32U
M$6 \$12 A1 \$7 SUB nfet_05v0 L=0.6U W=0.42U AS=0.1848P AD=0.0672P PS=1.72U
+ PD=0.74U
M$7 \$11 A2 \$12 SUB nfet_05v0 L=0.6U W=0.42U AS=0.0672P AD=0.0882P PS=0.74U
+ PD=0.84U
M$8 \$10 A3 \$11 SUB nfet_05v0 L=0.6U W=0.42U AS=0.0882P AD=0.0882P PS=0.84U
+ PD=0.84U
M$9 \$10 A4 VSS SUB nfet_05v0 L=0.6U W=0.42U AS=0.226P AD=0.0882P PS=1.515U
+ PD=0.84U
M$10 Z \$7 VSS SUB nfet_05v0 L=0.6U W=0.815U AS=0.226P AD=0.3586P PS=1.515U
+ PD=2.51U
.ENDS gf180mcu_fd_sc_mcu7t5v0__and4_1

.SUBCKT gf180mcu_fd_sc_mcu7t5v0__oai31_1 VSS VDD B A1 ZN A2 A3 \$12 SUB
M$1 ZN B VDD \$12 pfet_05v0 L=0.5U W=1.13U AS=0.4972P AD=0.4012P PS=3.14U
+ PD=1.85U
M$2 \$11 A1 ZN \$12 pfet_05v0 L=0.5U W=1.095U AS=0.4012P AD=0.58035P PS=1.85U
+ PD=2.155U
M$3 \$10 A2 \$11 \$12 pfet_05v0 L=0.5U W=1.095U AS=0.58035P AD=0.2847P
+ PS=2.155U PD=1.615U
M$4 VDD A3 \$10 \$12 pfet_05v0 L=0.5U W=1.095U AS=0.2847P AD=0.5913P PS=1.615U
+ PD=3.27U
M$5 \$4 B VSS SUB nfet_05v0 L=0.6U W=0.815U AS=0.3586P AD=0.2119P PS=2.51U
+ PD=1.335U
M$6 ZN A1 \$4 SUB nfet_05v0 L=0.6U W=0.815U AS=0.2119P AD=0.4137P PS=1.335U
+ PD=1.9U
M$7 \$4 A2 ZN SUB nfet_05v0 L=0.6U W=0.815U AS=0.4137P AD=0.2119P PS=1.9U
+ PD=1.335U
M$8 ZN A3 \$4 SUB nfet_05v0 L=0.6U W=0.815U AS=0.2119P AD=0.3586P PS=1.335U
+ PD=2.51U
.ENDS gf180mcu_fd_sc_mcu7t5v0__oai31_1

.SUBCKT gf180mcu_fd_sc_mcu7t5v0__or2_1 VSS A1 A2 VDD Z \$9 SUB
M$1 \$8 A1 \$5 \$9 pfet_05v0 L=0.5U W=0.565U AS=0.2486P AD=0.1469P PS=2.01U
+ PD=1.085U
M$2 \$8 A2 VDD \$9 pfet_05v0 L=0.5U W=0.565U AS=0.38705P AD=0.1469P PS=2.08U
+ PD=1.085U
M$3 Z \$5 VDD \$9 pfet_05v0 L=0.5U W=1.22U AS=0.38705P AD=0.5368P PS=2.08U
+ PD=3.32U
M$4 \$5 A1 VSS SUB nfet_05v0 L=0.6U W=0.36U AS=0.1584P AD=0.0936P PS=1.6U
+ PD=0.88U
M$5 \$5 A2 VSS SUB nfet_05v0 L=0.6U W=0.36U AS=0.2288P AD=0.0936P PS=1.58U
+ PD=0.88U
M$6 Z \$5 VSS SUB nfet_05v0 L=0.6U W=0.82U AS=0.2288P AD=0.3608P PS=1.58U
+ PD=2.52U
.ENDS gf180mcu_fd_sc_mcu7t5v0__or2_1

.SUBCKT gf180mcu_fd_sc_mcu7t5v0__aoi211_1 VSS A2 ZN A1 B C VDD \$12 SUB
M$1 ZN A2 \$2 \$12 pfet_05v0 L=0.5U W=1.215U AS=0.5346P AD=0.3159P PS=3.31U
+ PD=1.735U
M$2 \$2 A1 ZN \$12 pfet_05v0 L=0.5U W=1.215U AS=0.3159P AD=0.37665P PS=1.735U
+ PD=1.835U
M$3 \$11 B \$2 \$12 pfet_05v0 L=0.5U W=1.215U AS=0.37665P AD=0.37665P PS=1.835U
+ PD=1.835U
M$4 VDD C \$11 \$12 pfet_05v0 L=0.5U W=1.215U AS=0.37665P AD=0.5346P PS=1.835U
+ PD=3.31U
M$5 VSS B ZN SUB nfet_05v0 L=0.6U W=0.465U AS=0.21175P AD=0.1209P PS=1.41U
+ PD=0.985U
M$6 ZN C VSS SUB nfet_05v0 L=0.6U W=0.465U AS=0.1209P AD=0.2046P PS=0.985U
+ PD=1.81U
M$7 \$10 A2 VSS SUB nfet_05v0 L=0.6U W=0.71U AS=0.3124P AD=0.0852P PS=2.3U
+ PD=0.95U
M$8 ZN A1 \$10 SUB nfet_05v0 L=0.6U W=0.71U AS=0.0852P AD=0.21175P PS=0.95U
+ PD=1.41U
.ENDS gf180mcu_fd_sc_mcu7t5v0__aoi211_1

.SUBCKT gf180mcu_fd_sc_mcu7t5v0__or3_1 A1 VSS A2 A3 VDD Z \$11 SUB
M$1 \$10 A1 \$6 \$11 pfet_05v0 L=0.5U W=0.56U AS=0.2464P AD=0.1736P PS=2U
+ PD=1.18U
M$2 \$9 A2 \$10 \$11 pfet_05v0 L=0.5U W=0.56U AS=0.1736P AD=0.224P PS=1.18U
+ PD=1.36U
M$3 \$9 A3 VDD \$11 pfet_05v0 L=0.5U W=0.56U AS=0.389P AD=0.224P PS=2.02U
+ PD=1.36U
M$4 Z \$6 VDD \$11 pfet_05v0 L=0.5U W=1.22U AS=0.389P AD=0.5368P PS=2.02U
+ PD=3.32U
M$5 VSS A1 \$6 SUB nfet_05v0 L=0.6U W=0.4U AS=0.176P AD=0.104P PS=1.68U PD=0.92U
M$6 \$6 A2 VSS SUB nfet_05v0 L=0.6U W=0.4U AS=0.104P AD=0.14P PS=0.92U PD=1.1U
M$7 \$6 A3 VSS SUB nfet_05v0 L=0.6U W=0.4U AS=0.224P AD=0.14P PS=1.52U PD=1.1U
M$8 Z \$6 VSS SUB nfet_05v0 L=0.6U W=0.82U AS=0.224P AD=0.3608P PS=1.52U
+ PD=2.52U
.ENDS gf180mcu_fd_sc_mcu7t5v0__or3_1

.SUBCKT gf180mcu_fd_sc_mcu7t5v0__aoi22_1 VSS B2 VDD B1 ZN A1 A2 \$12 SUB
M$1 VDD B2 \$2 \$12 pfet_05v0 L=0.5U W=1.215U AS=0.5346P AD=0.3159P PS=3.31U
+ PD=1.735U
M$2 \$2 B1 VDD \$12 pfet_05v0 L=0.5U W=1.215U AS=0.3159P AD=0.3159P PS=1.735U
+ PD=1.735U
M$3 ZN A1 \$2 \$12 pfet_05v0 L=0.5U W=1.215U AS=0.3159P AD=0.3159P PS=1.735U
+ PD=1.735U
M$4 \$2 A2 ZN \$12 pfet_05v0 L=0.5U W=1.215U AS=0.3159P AD=0.5346P PS=1.735U
+ PD=3.31U
M$5 \$11 B2 VSS SUB nfet_05v0 L=0.6U W=0.815U AS=0.3586P AD=0.1304P PS=2.51U
+ PD=1.135U
M$6 ZN B1 \$11 SUB nfet_05v0 L=0.6U W=0.815U AS=0.1304P AD=0.2119P PS=1.135U
+ PD=1.335U
M$7 \$10 A1 ZN SUB nfet_05v0 L=0.6U W=0.815U AS=0.2119P AD=0.1304P PS=1.335U
+ PD=1.135U
M$8 VSS A2 \$10 SUB nfet_05v0 L=0.6U W=0.815U AS=0.1304P AD=0.3586P PS=1.135U
+ PD=2.51U
.ENDS gf180mcu_fd_sc_mcu7t5v0__aoi22_1

.SUBCKT gf180mcu_fd_sc_mcu7t5v0__xnor2_1 VDD A1 VSS ZN A2 \$11 SUB
M$1 \$1 A2 VDD \$11 pfet_05v0 L=0.5U W=0.56U AS=0.2464P AD=0.1456P PS=2U
+ PD=1.08U
M$2 \$1 A1 VDD \$11 pfet_05v0 L=0.5U W=0.56U AS=0.344375P AD=0.1456P PS=1.895U
+ PD=1.08U
M$3 ZN \$1 VDD \$11 pfet_05v0 L=0.5U W=1.095U AS=0.344375P AD=0.312075P
+ PS=1.895U PD=1.665U
M$4 \$10 A1 ZN \$11 pfet_05v0 L=0.5U W=1.095U AS=0.312075P AD=0.552975P
+ PS=1.665U PD=2.105U
M$5 VDD A2 \$10 \$11 pfet_05v0 L=0.5U W=1.095U AS=0.552975P AD=0.4818P
+ PS=2.105U PD=3.07U
M$6 \$9 A2 \$1 SUB nfet_05v0 L=0.6U W=0.36U AS=0.1584P AD=0.0576P PS=1.6U
+ PD=0.68U
M$7 \$9 A1 VSS SUB nfet_05v0 L=0.6U W=0.36U AS=0.218P AD=0.0576P PS=1.52U
+ PD=0.68U
M$8 \$5 \$1 VSS SUB nfet_05v0 L=0.6U W=0.82U AS=0.218P AD=0.2132P PS=1.52U
+ PD=1.34U
M$9 ZN A1 \$5 SUB nfet_05v0 L=0.6U W=0.82U AS=0.2132P AD=0.4161P PS=1.34U
+ PD=1.905U
M$10 \$5 A2 ZN SUB nfet_05v0 L=0.6U W=0.82U AS=0.4161P AD=0.3608P PS=1.905U
+ PD=2.52U
.ENDS gf180mcu_fd_sc_mcu7t5v0__xnor2_1

.SUBCKT gf180mcu_fd_sc_mcu7t5v0__nor4_1 VSS VDD A4 ZN A3 A2 A1 \$12 SUB
M$1 \$11 A4 VDD \$12 pfet_05v0 L=0.5U W=1.22U AS=0.5368P AD=0.3172P PS=3.32U
+ PD=1.74U
M$2 \$10 A3 \$11 \$12 pfet_05v0 L=0.5U W=1.22U AS=0.3172P AD=0.3782P PS=1.74U
+ PD=1.84U
M$3 \$9 A2 \$10 \$12 pfet_05v0 L=0.5U W=1.22U AS=0.3782P AD=0.3782P PS=1.84U
+ PD=1.84U
M$4 ZN A1 \$9 \$12 pfet_05v0 L=0.5U W=1.22U AS=0.3782P AD=0.5368P PS=1.84U
+ PD=3.32U
M$5 ZN A4 VSS SUB nfet_05v0 L=0.6U W=0.36U AS=0.1584P AD=0.0936P PS=1.6U
+ PD=0.88U
M$6 VSS A3 ZN SUB nfet_05v0 L=0.6U W=0.36U AS=0.0936P AD=0.0936P PS=0.88U
+ PD=0.88U
M$7 ZN A2 VSS SUB nfet_05v0 L=0.6U W=0.36U AS=0.0936P AD=0.0936P PS=0.88U
+ PD=0.88U
M$8 VSS A1 ZN SUB nfet_05v0 L=0.6U W=0.36U AS=0.0936P AD=0.1584P PS=0.88U
+ PD=1.6U
.ENDS gf180mcu_fd_sc_mcu7t5v0__nor4_1

.SUBCKT gf180mcu_fd_sc_mcu7t5v0__nand4_1 VSS VDD A4 ZN A3 A2 A1 \$12 SUB
M$1 ZN A4 VDD \$12 pfet_05v0 L=0.5U W=0.845U AS=0.3718P AD=0.2197P PS=2.57U
+ PD=1.365U
M$2 VDD A3 ZN \$12 pfet_05v0 L=0.5U W=0.845U AS=0.2197P AD=0.2197P PS=1.365U
+ PD=1.365U
M$3 ZN A2 VDD \$12 pfet_05v0 L=0.5U W=0.845U AS=0.2197P AD=0.2197P PS=1.365U
+ PD=1.365U
M$4 VDD A1 ZN \$12 pfet_05v0 L=0.5U W=0.845U AS=0.2197P AD=0.3718P PS=1.365U
+ PD=2.57U
M$5 \$11 A4 VSS SUB nfet_05v0 L=0.6U W=0.82U AS=0.3608P AD=0.1517P PS=2.52U
+ PD=1.19U
M$6 \$10 A3 \$11 SUB nfet_05v0 L=0.6U W=0.82U AS=0.1517P AD=0.1722P PS=1.19U
+ PD=1.24U
M$7 \$9 A2 \$10 SUB nfet_05v0 L=0.6U W=0.82U AS=0.1722P AD=0.1517P PS=1.24U
+ PD=1.19U
M$8 ZN A1 \$9 SUB nfet_05v0 L=0.6U W=0.82U AS=0.1517P AD=0.3608P PS=1.19U
+ PD=2.52U
.ENDS gf180mcu_fd_sc_mcu7t5v0__nand4_1

.SUBCKT gf180mcu_fd_sc_mcu7t5v0__nor3_1 VSS VDD A3 ZN A2 A1 \$10 SUB
M$1 \$9 A3 VDD \$10 pfet_05v0 L=0.5U W=1.22U AS=0.5368P AD=0.3172P PS=3.32U
+ PD=1.74U
M$2 \$8 A2 \$9 \$10 pfet_05v0 L=0.5U W=1.22U AS=0.3172P AD=0.3782P PS=1.74U
+ PD=1.84U
M$3 ZN A1 \$8 \$10 pfet_05v0 L=0.5U W=1.22U AS=0.3782P AD=0.5368P PS=1.84U
+ PD=3.32U
M$4 ZN A3 VSS SUB nfet_05v0 L=0.6U W=0.465U AS=0.2046P AD=0.1209P PS=1.81U
+ PD=0.985U
M$5 VSS A2 ZN SUB nfet_05v0 L=0.6U W=0.465U AS=0.1209P AD=0.1209P PS=0.985U
+ PD=0.985U
M$6 ZN A1 VSS SUB nfet_05v0 L=0.6U W=0.465U AS=0.1209P AD=0.2046P PS=0.985U
+ PD=1.81U
.ENDS gf180mcu_fd_sc_mcu7t5v0__nor3_1

.SUBCKT gf180mcu_fd_sc_mcu7t5v0__fillcap_32 VSS VDD \$21 SUB
M$1 VDD \$17 \$9 \$21 pfet_05v0 L=1U W=1.22U AS=0.5368P AD=0.5368P PS=3.32U
+ PD=3.32U
M$2 VDD \$16 \$8 \$21 pfet_05v0 L=1U W=1.22U AS=0.5368P AD=0.5368P PS=3.32U
+ PD=3.32U
M$3 VDD \$15 \$7 \$21 pfet_05v0 L=1U W=1.22U AS=0.5368P AD=0.5368P PS=3.32U
+ PD=3.32U
M$4 VDD \$14 \$6 \$21 pfet_05v0 L=1U W=1.22U AS=0.5368P AD=0.5368P PS=3.32U
+ PD=3.32U
M$5 VDD \$13 \$5 \$21 pfet_05v0 L=1U W=1.22U AS=0.5368P AD=0.5368P PS=3.32U
+ PD=3.32U
M$6 VDD \$12 \$4 \$21 pfet_05v0 L=1U W=1.22U AS=0.5368P AD=0.5368P PS=3.32U
+ PD=3.32U
M$7 VDD \$11 \$3 \$21 pfet_05v0 L=1U W=1.22U AS=0.5368P AD=0.5368P PS=3.32U
+ PD=3.32U
M$8 VDD \$10 \$2 \$21 pfet_05v0 L=1U W=1.22U AS=0.5368P AD=0.5368P PS=3.32U
+ PD=3.32U
M$9 \$14 \$6 VSS SUB nfet_05v0 L=1U W=0.82U AS=0.3608P AD=0.3608P PS=2.52U
+ PD=2.52U
M$10 \$11 \$3 VSS SUB nfet_05v0 L=1U W=0.82U AS=0.3608P AD=0.3608P PS=2.52U
+ PD=2.52U
M$11 \$13 \$5 VSS SUB nfet_05v0 L=1U W=0.82U AS=0.3608P AD=0.3608P PS=2.52U
+ PD=2.52U
M$12 \$16 \$8 VSS SUB nfet_05v0 L=1U W=0.82U AS=0.3608P AD=0.3608P PS=2.52U
+ PD=2.52U
M$13 \$12 \$4 VSS SUB nfet_05v0 L=1U W=0.82U AS=0.3608P AD=0.3608P PS=2.52U
+ PD=2.52U
M$14 \$15 \$7 VSS SUB nfet_05v0 L=1U W=0.82U AS=0.3608P AD=0.3608P PS=2.52U
+ PD=2.52U
M$15 \$17 \$9 VSS SUB nfet_05v0 L=1U W=0.82U AS=0.3608P AD=0.3608P PS=2.52U
+ PD=2.52U
M$16 \$10 \$2 VSS SUB nfet_05v0 L=1U W=0.82U AS=0.3608P AD=0.3608P PS=2.52U
+ PD=2.52U
.ENDS gf180mcu_fd_sc_mcu7t5v0__fillcap_32

.SUBCKT gf180mcu_fd_sc_mcu7t5v0__fillcap_64 VSS VDD \$36 SUB
M$1 VDD \$24 \$8 \$36 pfet_05v0 L=1U W=1.22U AS=0.5368P AD=0.5368P PS=3.32U
+ PD=3.32U
M$2 VDD \$23 \$7 \$36 pfet_05v0 L=1U W=1.22U AS=0.5368P AD=0.5368P PS=3.32U
+ PD=3.32U
M$3 VDD \$22 \$6 \$36 pfet_05v0 L=1U W=1.22U AS=0.5368P AD=0.5368P PS=3.32U
+ PD=3.32U
M$4 VDD \$29 \$13 \$36 pfet_05v0 L=1U W=1.22U AS=0.5368P AD=0.5368P PS=3.32U
+ PD=3.32U
M$5 VDD \$28 \$12 \$36 pfet_05v0 L=1U W=1.22U AS=0.5368P AD=0.5368P PS=3.32U
+ PD=3.32U
M$6 VDD \$25 \$9 \$36 pfet_05v0 L=1U W=1.22U AS=0.5368P AD=0.5368P PS=3.32U
+ PD=3.32U
M$7 VDD \$32 \$16 \$36 pfet_05v0 L=1U W=1.22U AS=0.5368P AD=0.5368P PS=3.32U
+ PD=3.32U
M$8 VDD \$33 \$17 \$36 pfet_05v0 L=1U W=1.22U AS=0.5368P AD=0.5368P PS=3.32U
+ PD=3.32U
M$9 VDD \$31 \$15 \$36 pfet_05v0 L=1U W=1.22U AS=0.5368P AD=0.5368P PS=3.32U
+ PD=3.32U
M$10 VDD \$18 \$2 \$36 pfet_05v0 L=1U W=1.22U AS=0.5368P AD=0.5368P PS=3.32U
+ PD=3.32U
M$11 VDD \$19 \$3 \$36 pfet_05v0 L=1U W=1.22U AS=0.5368P AD=0.5368P PS=3.32U
+ PD=3.32U
M$12 VDD \$26 \$10 \$36 pfet_05v0 L=1U W=1.22U AS=0.5368P AD=0.5368P PS=3.32U
+ PD=3.32U
M$13 VDD \$27 \$11 \$36 pfet_05v0 L=1U W=1.22U AS=0.5368P AD=0.5368P PS=3.32U
+ PD=3.32U
M$14 VDD \$20 \$4 \$36 pfet_05v0 L=1U W=1.22U AS=0.5368P AD=0.5368P PS=3.32U
+ PD=3.32U
M$15 VDD \$21 \$5 \$36 pfet_05v0 L=1U W=1.22U AS=0.5368P AD=0.5368P PS=3.32U
+ PD=3.32U
M$16 VDD \$30 \$14 \$36 pfet_05v0 L=1U W=1.22U AS=0.5368P AD=0.5368P PS=3.32U
+ PD=3.32U
M$17 \$29 \$13 VSS SUB nfet_05v0 L=1U W=0.82U AS=0.3608P AD=0.3608P PS=2.52U
+ PD=2.52U
M$18 \$28 \$12 VSS SUB nfet_05v0 L=1U W=0.82U AS=0.3608P AD=0.3608P PS=2.52U
+ PD=2.52U
M$19 \$24 \$8 VSS SUB nfet_05v0 L=1U W=0.82U AS=0.3608P AD=0.3608P PS=2.52U
+ PD=2.52U
M$20 \$21 \$5 VSS SUB nfet_05v0 L=1U W=0.82U AS=0.3608P AD=0.3608P PS=2.52U
+ PD=2.52U
M$21 \$30 \$14 VSS SUB nfet_05v0 L=1U W=0.82U AS=0.3608P AD=0.3608P PS=2.52U
+ PD=2.52U
M$22 \$23 \$7 VSS SUB nfet_05v0 L=1U W=0.82U AS=0.3608P AD=0.3608P PS=2.52U
+ PD=2.52U
M$23 \$22 \$6 VSS SUB nfet_05v0 L=1U W=0.82U AS=0.3608P AD=0.3608P PS=2.52U
+ PD=2.52U
M$24 \$32 \$16 VSS SUB nfet_05v0 L=1U W=0.82U AS=0.3608P AD=0.3608P PS=2.52U
+ PD=2.52U
M$25 \$20 \$4 VSS SUB nfet_05v0 L=1U W=0.82U AS=0.3608P AD=0.3608P PS=2.52U
+ PD=2.52U
M$26 \$33 \$17 VSS SUB nfet_05v0 L=1U W=0.82U AS=0.3608P AD=0.3608P PS=2.52U
+ PD=2.52U
M$27 \$19 \$3 VSS SUB nfet_05v0 L=1U W=0.82U AS=0.3608P AD=0.3608P PS=2.52U
+ PD=2.52U
M$28 \$31 \$15 VSS SUB nfet_05v0 L=1U W=0.82U AS=0.3608P AD=0.3608P PS=2.52U
+ PD=2.52U
M$29 \$18 \$2 VSS SUB nfet_05v0 L=1U W=0.82U AS=0.3608P AD=0.3608P PS=2.52U
+ PD=2.52U
M$30 \$25 \$9 VSS SUB nfet_05v0 L=1U W=0.82U AS=0.3608P AD=0.3608P PS=2.52U
+ PD=2.52U
M$31 \$26 \$10 VSS SUB nfet_05v0 L=1U W=0.82U AS=0.3608P AD=0.3608P PS=2.52U
+ PD=2.52U
M$32 \$27 \$11 VSS SUB nfet_05v0 L=1U W=0.82U AS=0.3608P AD=0.3608P PS=2.52U
+ PD=2.52U
.ENDS gf180mcu_fd_sc_mcu7t5v0__fillcap_64

.SUBCKT gf180mcu_fd_sc_mcu7t5v0__fillcap_16 VSS VDD \$12 SUB
M$1 VDD \$10 \$9 \$12 pfet_05v0 L=1U W=1.22U AS=0.5368P AD=0.5368P PS=3.32U
+ PD=3.32U
M$2 VDD \$7 \$6 \$12 pfet_05v0 L=1U W=1.22U AS=0.5368P AD=0.5368P PS=3.32U
+ PD=3.32U
M$3 VDD \$5 \$4 \$12 pfet_05v0 L=1U W=1.22U AS=0.5368P AD=0.5368P PS=3.32U
+ PD=3.32U
M$4 VDD \$3 \$2 \$12 pfet_05v0 L=1U W=1.22U AS=0.5368P AD=0.5368P PS=3.32U
+ PD=3.32U
M$5 \$10 \$9 VSS SUB nfet_05v0 L=1U W=0.82U AS=0.3608P AD=0.3608P PS=2.52U
+ PD=2.52U
M$6 \$7 \$6 VSS SUB nfet_05v0 L=1U W=0.82U AS=0.3608P AD=0.3608P PS=2.52U
+ PD=2.52U
M$7 \$5 \$4 VSS SUB nfet_05v0 L=1U W=0.82U AS=0.3608P AD=0.3608P PS=2.52U
+ PD=2.52U
M$8 \$3 \$2 VSS SUB nfet_05v0 L=1U W=0.82U AS=0.3608P AD=0.3608P PS=2.52U
+ PD=2.52U
.ENDS gf180mcu_fd_sc_mcu7t5v0__fillcap_16

.SUBCKT gf180mcu_fd_sc_mcu7t5v0__nand3_1 VSS VDD A3 ZN A2 A1 \$10 SUB
M$1 ZN A3 VDD \$10 pfet_05v0 L=0.5U W=0.985U AS=0.4334P AD=0.2561P PS=2.85U
+ PD=1.505U
M$2 VDD A2 ZN \$10 pfet_05v0 L=0.5U W=0.985U AS=0.2561P AD=0.2561P PS=1.505U
+ PD=1.505U
M$3 ZN A1 VDD \$10 pfet_05v0 L=0.5U W=0.985U AS=0.2561P AD=0.4334P PS=1.505U
+ PD=2.85U
M$4 \$9 A3 VSS SUB nfet_05v0 L=0.6U W=0.82U AS=0.3608P AD=0.1312P PS=2.52U
+ PD=1.14U
M$5 \$8 A2 \$9 SUB nfet_05v0 L=0.6U W=0.82U AS=0.1312P AD=0.1722P PS=1.14U
+ PD=1.24U
M$6 ZN A1 \$8 SUB nfet_05v0 L=0.6U W=0.82U AS=0.1722P AD=0.3608P PS=1.24U
+ PD=2.52U
.ENDS gf180mcu_fd_sc_mcu7t5v0__nand3_1

.SUBCKT gf180mcu_fd_sc_mcu7t5v0__oai22_1 VDD B2 VSS B1 A1 ZN A2 \$12 SUB
M$1 \$11 B2 VDD \$12 pfet_05v0 L=0.5U W=1.22U AS=0.6588P AD=0.3782P PS=3.52U
+ PD=1.84U
M$2 ZN B1 \$11 \$12 pfet_05v0 L=0.5U W=1.22U AS=0.3782P AD=0.3782P PS=1.84U
+ PD=1.84U
M$3 \$10 A1 ZN \$12 pfet_05v0 L=0.5U W=1.22U AS=0.3782P AD=0.3172P PS=1.84U
+ PD=1.74U
M$4 VDD A2 \$10 \$12 pfet_05v0 L=0.5U W=1.22U AS=0.3172P AD=0.5368P PS=1.74U
+ PD=3.32U
M$5 VSS B2 \$1 SUB nfet_05v0 L=0.6U W=0.82U AS=0.3608P AD=0.2132P PS=2.52U
+ PD=1.34U
M$6 \$1 B1 VSS SUB nfet_05v0 L=0.6U W=0.82U AS=0.2132P AD=0.2132P PS=1.34U
+ PD=1.34U
M$7 ZN A1 \$1 SUB nfet_05v0 L=0.6U W=0.82U AS=0.2132P AD=0.2132P PS=1.34U
+ PD=1.34U
M$8 \$1 A2 ZN SUB nfet_05v0 L=0.6U W=0.82U AS=0.2132P AD=0.3608P PS=1.34U
+ PD=2.52U
.ENDS gf180mcu_fd_sc_mcu7t5v0__oai22_1

.SUBCKT gf180mcu_fd_sc_mcu7t5v0__clkbuf_1 I VSS VDD Z \$7 SUB
M$1 \$1 I VDD \$7 pfet_05v0 L=0.5U W=1.05U AS=0.4015P AD=0.462P PS=1.92U
+ PD=2.98U
M$2 Z \$1 VDD \$7 pfet_05v0 L=0.5U W=1.22U AS=0.4015P AD=0.5368P PS=1.92U
+ PD=3.32U
M$3 VSS I \$1 SUB nfet_05v0 L=0.6U W=0.36U AS=0.1584P AD=0.153P PS=1.6U
+ PD=1.195U
M$4 Z \$1 VSS SUB nfet_05v0 L=0.6U W=0.495U AS=0.153P AD=0.2178P PS=1.195U
+ PD=1.87U
.ENDS gf180mcu_fd_sc_mcu7t5v0__clkbuf_1

.SUBCKT gf180mcu_fd_sc_mcu7t5v0__clkbuf_2 I VDD VSS \$7 SUB
M$1 \$4 I VDD \$7 pfet_05v0 L=0.5U W=1.02U AS=0.458P AD=0.4488P PS=2.02U
+ PD=2.92U
M$2 Z \$4 VDD \$7 pfet_05v0 L=0.5U W=2.44U AS=0.8362P AD=0.915P PS=3.86U
+ PD=5.16U
M$4 \$4 I VSS SUB nfet_05v0 L=0.6U W=0.36U AS=0.151P AD=0.1584P PS=1.185U
+ PD=1.6U
M$5 Z \$4 VSS SUB nfet_05v0 L=0.6U W=0.97U AS=0.2771P AD=0.3395P PS=2.19U
+ PD=2.855U
.ENDS gf180mcu_fd_sc_mcu7t5v0__clkbuf_2

.SUBCKT gf180mcu_fd_sc_mcu7t5v0__mux2_2 VSS VDD Z I1 S I0 \$14 SUB
M$1 Z \$6 VDD \$14 pfet_05v0 L=0.5U W=2.44U AS=0.8845P AD=0.7869P PS=5.11U
+ PD=3.73U
M$3 \$13 I1 VDD \$14 pfet_05v0 L=0.5U W=1.22U AS=0.4392P AD=0.4758P PS=1.94U
+ PD=2U
M$4 \$6 \$8 \$13 \$14 pfet_05v0 L=0.5U W=1.22U AS=0.4758P AD=0.3172P PS=2U
+ PD=1.74U
M$5 \$12 S \$6 \$14 pfet_05v0 L=0.5U W=1.22U AS=0.3172P AD=0.1464P PS=1.74U
+ PD=1.46U
M$6 VDD I0 \$12 \$14 pfet_05v0 L=0.5U W=1.22U AS=0.1464P AD=0.3172P PS=1.46U
+ PD=1.74U
M$7 \$8 S VDD \$14 pfet_05v0 L=0.5U W=1.22U AS=0.3172P AD=0.5368P PS=1.74U
+ PD=3.32U
M$8 Z \$6 VSS SUB nfet_05v0 L=0.6U W=1.64U AS=0.574P AD=0.4264P PS=3.86U
+ PD=2.68U
M$10 \$11 I1 VSS SUB nfet_05v0 L=0.6U W=0.82U AS=0.2132P AD=0.0984P PS=1.34U
+ PD=1.06U
M$11 \$6 S \$11 SUB nfet_05v0 L=0.6U W=0.82U AS=0.0984P AD=0.2132P PS=1.06U
+ PD=1.34U
M$12 \$10 \$8 \$6 SUB nfet_05v0 L=0.6U W=0.82U AS=0.2132P AD=0.1968P PS=1.34U
+ PD=1.3U
M$13 VSS I0 \$10 SUB nfet_05v0 L=0.6U W=0.82U AS=0.1968P AD=0.2132P PS=1.3U
+ PD=1.34U
M$14 \$8 S VSS SUB nfet_05v0 L=0.6U W=0.82U AS=0.2132P AD=0.3608P PS=1.34U
+ PD=2.52U
.ENDS gf180mcu_fd_sc_mcu7t5v0__mux2_2

.SUBCKT gf180mcu_fd_sc_mcu7t5v0__fillcap_8 VSS VDD \$8 SUB
M$1 VDD \$6 \$5 \$8 pfet_05v0 L=1U W=1.22U AS=0.5368P AD=0.5368P PS=3.32U
+ PD=3.32U
M$2 VDD \$3 \$2 \$8 pfet_05v0 L=1U W=1.22U AS=0.5368P AD=0.5368P PS=3.32U
+ PD=3.32U
M$3 \$6 \$5 VSS SUB nfet_05v0 L=1U W=0.82U AS=0.3608P AD=0.3608P PS=2.52U
+ PD=2.52U
M$4 \$3 \$2 VSS SUB nfet_05v0 L=1U W=0.82U AS=0.3608P AD=0.3608P PS=2.52U
+ PD=2.52U
.ENDS gf180mcu_fd_sc_mcu7t5v0__fillcap_8

.SUBCKT gf180mcu_fd_sc_mcu7t5v0__xor2_1 VSS A2 A1 VDD Z \$11 SUB
M$1 \$10 A2 \$5 \$11 pfet_05v0 L=0.5U W=0.56U AS=0.2464P AD=0.1456P PS=2U
+ PD=1.08U
M$2 \$10 A1 VDD \$11 pfet_05v0 L=0.5U W=0.56U AS=0.4005P AD=0.1456P PS=2.12U
+ PD=1.08U
M$3 \$6 \$5 VDD \$11 pfet_05v0 L=0.5U W=1.22U AS=0.4005P AD=0.3172P PS=2.12U
+ PD=1.74U
M$4 Z A1 \$6 \$11 pfet_05v0 L=0.5U W=1.22U AS=0.3172P AD=0.3172P PS=1.74U
+ PD=1.74U
M$5 \$6 A2 Z \$11 pfet_05v0 L=0.5U W=1.22U AS=0.3172P AD=0.5368P PS=1.74U
+ PD=3.32U
M$6 \$5 A2 VSS SUB nfet_05v0 L=0.6U W=0.36U AS=0.1584P AD=0.0936P PS=1.6U
+ PD=0.88U
M$7 \$5 A1 VSS SUB nfet_05v0 L=0.6U W=0.36U AS=0.218P AD=0.0936P PS=1.52U
+ PD=0.88U
M$8 Z \$5 VSS SUB nfet_05v0 L=0.6U W=0.82U AS=0.218P AD=0.2132P PS=1.52U
+ PD=1.34U
M$9 \$9 A1 Z SUB nfet_05v0 L=0.6U W=0.82U AS=0.2132P AD=0.1312P PS=1.34U
+ PD=1.14U
M$10 VSS A2 \$9 SUB nfet_05v0 L=0.6U W=0.82U AS=0.1312P AD=0.3608P PS=1.14U
+ PD=2.52U
.ENDS gf180mcu_fd_sc_mcu7t5v0__xor2_1

.SUBCKT gf180mcu_fd_sc_mcu7t5v0__and2_1 VDD A1 A2 VSS Z \$9 SUB
M$1 \$5 A1 VDD \$9 pfet_05v0 L=0.5U W=0.6U AS=0.264P AD=0.156P PS=2.08U PD=1.12U
M$2 \$5 A2 VDD \$9 pfet_05v0 L=0.5U W=0.6U AS=0.40575P AD=0.156P PS=2.055U
+ PD=1.12U
M$3 Z \$5 VDD \$9 pfet_05v0 L=0.5U W=1.215U AS=0.40575P AD=0.5346P PS=2.055U
+ PD=3.31U
M$4 \$8 A1 \$5 SUB nfet_05v0 L=0.6U W=0.365U AS=0.1606P AD=0.0584P PS=1.61U
+ PD=0.685U
M$5 \$8 A2 VSS SUB nfet_05v0 L=0.6U W=0.365U AS=0.23405P AD=0.0584P PS=1.555U
+ PD=0.685U
M$6 Z \$5 VSS SUB nfet_05v0 L=0.6U W=0.815U AS=0.23405P AD=0.3586P PS=1.555U
+ PD=2.51U
.ENDS gf180mcu_fd_sc_mcu7t5v0__and2_1

.SUBCKT gf180mcu_fd_sc_mcu7t5v0__fillcap_4 VSS VDD \$6 SUB
M$1 VDD \$3 \$2 \$6 pfet_05v0 L=1U W=1.22U AS=0.5368P AD=0.5368P PS=3.32U
+ PD=3.32U
M$2 \$3 \$2 VSS SUB nfet_05v0 L=1U W=0.82U AS=0.3608P AD=0.3608P PS=2.52U
+ PD=2.52U
.ENDS gf180mcu_fd_sc_mcu7t5v0__fillcap_4

.SUBCKT gf180mcu_fd_sc_mcu7t5v0__nand2_1 VSS VDD A2 A1 ZN \$8 SUB
M$1 ZN A2 VDD \$8 pfet_05v0 L=0.5U W=1.13U AS=0.4972P AD=0.2938P PS=3.14U
+ PD=1.65U
M$2 VDD A1 ZN \$8 pfet_05v0 L=0.5U W=1.13U AS=0.2938P AD=0.4972P PS=1.65U
+ PD=3.14U
M$3 \$7 A2 VSS SUB nfet_05v0 L=0.6U W=0.82U AS=0.3608P AD=0.1312P PS=2.52U
+ PD=1.14U
M$4 ZN A1 \$7 SUB nfet_05v0 L=0.6U W=0.82U AS=0.1312P AD=0.3608P PS=1.14U
+ PD=2.52U
.ENDS gf180mcu_fd_sc_mcu7t5v0__nand2_1

.SUBCKT gf180mcu_fd_sc_mcu7t5v0__clkbuf_16 VSS I Z VDD \$8 SUB
M$1 \$3 I VDD \$8 pfet_05v0 L=0.5U W=6.56U AS=2.314P AD=2.0336P PS=13.18U
+ PD=11.52U
M$9 Z \$3 VDD \$8 pfet_05v0 L=0.5U W=19.52U AS=6.101P AD=6.2098P PS=29.62U
+ PD=30.92U
M$25 Z \$3 VSS SUB nfet_05v0 L=0.6U W=7.76U AS=2.1049P AD=2.1049P PS=16.925U
+ PD=16.925U
M$41 VSS I \$3 SUB nfet_05v0 L=0.6U W=2.43U AS=0.7047P AD=0.7047P PS=6.315U
+ PD=6.315U
.ENDS gf180mcu_fd_sc_mcu7t5v0__clkbuf_16

.SUBCKT gf180mcu_fd_sc_mcu7t5v0__oai21_1 VDD A2 ZN A1 B VSS \$10 SUB
M$1 \$9 A2 VDD \$10 pfet_05v0 L=0.5U W=1.22U AS=0.5978P AD=0.3172P PS=3.42U
+ PD=1.74U
M$2 ZN A1 \$9 \$10 pfet_05v0 L=0.5U W=1.22U AS=0.3172P AD=0.4248P PS=1.74U
+ PD=1.94U
M$3 VDD B ZN \$10 pfet_05v0 L=0.5U W=1.13U AS=0.4248P AD=0.4972P PS=1.94U
+ PD=3.14U
M$4 ZN A2 \$5 SUB nfet_05v0 L=0.6U W=0.82U AS=0.3608P AD=0.2132P PS=2.52U
+ PD=1.34U
M$5 \$5 A1 ZN SUB nfet_05v0 L=0.6U W=0.82U AS=0.2132P AD=0.2132P PS=1.34U
+ PD=1.34U
M$6 VSS B \$5 SUB nfet_05v0 L=0.6U W=0.82U AS=0.2132P AD=0.3608P PS=1.34U
+ PD=2.52U
.ENDS gf180mcu_fd_sc_mcu7t5v0__oai21_1

.SUBCKT gf180mcu_fd_sc_mcu7t5v0__clkinv_1 VSS VDD I ZN \$6 SUB
M$1 ZN I VDD \$6 pfet_05v0 L=0.5U W=1.22U AS=0.5368P AD=0.5368P PS=3.32U
+ PD=3.32U
M$2 ZN I VSS SUB nfet_05v0 L=0.6U W=0.48U AS=0.2112P AD=0.2112P PS=1.84U
+ PD=1.84U
.ENDS gf180mcu_fd_sc_mcu7t5v0__clkinv_1

.SUBCKT gf180mcu_fd_sc_mcu7t5v0__dffsnq_1 VSS Q CLK D SETN VDD \$21 SUB
M$1 VDD CLK \$3 \$21 pfet_05v0 L=0.5U W=0.865U AS=0.3806P AD=0.2249P PS=2.61U
+ PD=1.385U
M$2 \$4 \$3 VDD \$21 pfet_05v0 L=0.5U W=0.865U AS=0.2249P AD=0.3806P PS=1.385U
+ PD=2.61U
M$3 \$8 SETN VDD \$21 pfet_05v0 L=0.5U W=0.78U AS=0.3432P AD=0.2028P PS=2.44U
+ PD=1.3U
M$4 VDD \$9 \$8 \$21 pfet_05v0 L=0.5U W=0.78U AS=0.2028P AD=0.3276P PS=1.3U
+ PD=1.62U
M$5 \$9 \$2 VDD \$21 pfet_05v0 L=0.5U W=0.78U AS=0.3276P AD=0.3432P PS=1.62U
+ PD=2.44U
M$6 \$2 \$3 \$7 \$21 pfet_05v0 L=0.5U W=0.415U AS=0.27805P AD=0.1079P PS=2.17U
+ PD=0.935U
M$7 \$8 \$4 \$2 \$21 pfet_05v0 L=0.5U W=0.415U AS=0.1079P AD=0.1826P PS=0.935U
+ PD=1.71U
M$8 Q \$9 VDD \$21 pfet_05v0 L=0.5U W=1.215U AS=0.5346P AD=0.6561P PS=3.31U
+ PD=3.51U
M$9 \$5 D VDD \$21 pfet_05v0 L=0.5U W=0.505U AS=0.22725P AD=0.1313P PS=1.91U
+ PD=1.025U
M$10 \$6 \$4 \$5 \$21 pfet_05v0 L=0.5U W=0.505U AS=0.1313P AD=0.1931625P
+ PS=1.025U PD=1.27U
M$11 \$19 \$3 \$6 \$21 pfet_05v0 L=0.5U W=0.505U AS=0.1931625P AD=0.101P
+ PS=1.27U PD=0.905U
M$12 VDD \$7 \$19 \$21 pfet_05v0 L=0.5U W=0.505U AS=0.101P AD=0.3975P PS=0.905U
+ PD=2.185U
M$13 \$7 \$6 VDD \$21 pfet_05v0 L=0.5U W=0.585U AS=0.3975P AD=0.1521P PS=2.185U
+ PD=1.105U
M$14 VDD SETN \$7 \$21 pfet_05v0 L=0.5U W=0.585U AS=0.1521P AD=0.4149P
+ PS=1.105U PD=2.65U
M$15 \$16 SETN \$8 SUB nfet_05v0 L=0.6U W=0.405U AS=0.3123P AD=0.0486P PS=2.38U
+ PD=0.645U
M$16 VSS \$9 \$16 SUB nfet_05v0 L=0.6U W=0.405U AS=0.0486P AD=0.14985P
+ PS=0.645U PD=1.145U
M$17 \$9 \$2 VSS SUB nfet_05v0 L=0.6U W=0.405U AS=0.14985P AD=0.1782P PS=1.145U
+ PD=1.69U
M$18 VSS CLK \$3 SUB nfet_05v0 L=0.6U W=0.405U AS=0.1782P AD=0.1053P PS=1.69U
+ PD=0.925U
M$19 \$4 \$3 VSS SUB nfet_05v0 L=0.6U W=0.405U AS=0.1053P AD=0.1782P PS=0.925U
+ PD=1.69U
M$20 \$5 D VSS SUB nfet_05v0 L=0.6U W=0.36U AS=0.1584P AD=0.0936P PS=1.6U
+ PD=0.88U
M$21 \$6 \$3 \$5 SUB nfet_05v0 L=0.6U W=0.36U AS=0.0936P AD=0.0936P PS=0.88U
+ PD=0.88U
M$22 \$15 \$4 \$6 SUB nfet_05v0 L=0.6U W=0.36U AS=0.0936P AD=0.0621P PS=0.88U
+ PD=0.705U
M$23 VSS \$7 \$15 SUB nfet_05v0 L=0.6U W=0.36U AS=0.0621P AD=0.0936P PS=0.705U
+ PD=0.88U
M$24 \$17 \$6 VSS SUB nfet_05v0 L=0.6U W=0.36U AS=0.0936P AD=0.0864P PS=0.88U
+ PD=0.84U
M$25 \$7 SETN \$17 SUB nfet_05v0 L=0.6U W=0.36U AS=0.0864P AD=0.1989P PS=0.84U
+ PD=1.465U
M$26 \$2 \$4 \$7 SUB nfet_05v0 L=0.6U W=0.36U AS=0.1989P AD=0.0936P PS=1.465U
+ PD=0.88U
M$27 \$8 \$3 \$2 SUB nfet_05v0 L=0.6U W=0.36U AS=0.0936P AD=0.2898P PS=0.88U
+ PD=2.33U
M$28 Q \$9 VSS SUB nfet_05v0 L=0.6U W=0.815U AS=0.3586P AD=0.3586P PS=2.51U
+ PD=2.51U
.ENDS gf180mcu_fd_sc_mcu7t5v0__dffsnq_1

.SUBCKT gf180mcu_fd_sc_mcu7t5v0__clkbuf_8 VSS I Z VDD \$7 SUB
M$1 \$3 I VDD \$7 pfet_05v0 L=0.5U W=3.28U AS=1.2362P AD=1.0988P PS=7.32U
+ PD=5.96U
M$5 Z \$3 VDD \$7 pfet_05v0 L=0.5U W=9.76U AS=3.0754P AD=3.2452P PS=14.9U
+ PD=16.3U
M$13 \$3 I VSS SUB nfet_05v0 L=0.6U W=1.215U AS=0.3888P AD=0.3888P PS=3.54U
+ PD=3.54U
M$16 Z \$3 VSS SUB nfet_05v0 L=0.6U W=3.44U AS=0.9718P AD=0.9718P PS=8.39U
+ PD=8.39U
.ENDS gf180mcu_fd_sc_mcu7t5v0__clkbuf_8

.SUBCKT gf180mcu_fd_sc_mcu7t5v0__aoi21_1 VSS A2 ZN A1 B VDD \$10 SUB
M$1 ZN A2 \$2 \$10 pfet_05v0 L=0.5U W=1.215U AS=0.5346P AD=0.3159P PS=3.31U
+ PD=1.735U
M$2 \$2 A1 ZN \$10 pfet_05v0 L=0.5U W=1.215U AS=0.3159P AD=0.44955P PS=1.735U
+ PD=1.955U
M$3 VDD B \$2 \$10 pfet_05v0 L=0.5U W=1.215U AS=0.44955P AD=0.5346P PS=1.955U
+ PD=3.31U
M$4 VSS B ZN SUB nfet_05v0 L=0.6U W=0.51U AS=0.2569P AD=0.2244P PS=1.56U PD=1.9U
M$5 \$9 A2 VSS SUB nfet_05v0 L=0.6U W=0.82U AS=0.3608P AD=0.1312P PS=2.52U
+ PD=1.14U
M$6 ZN A1 \$9 SUB nfet_05v0 L=0.6U W=0.82U AS=0.1312P AD=0.2569P PS=1.14U
+ PD=1.56U
.ENDS gf180mcu_fd_sc_mcu7t5v0__aoi21_1

.SUBCKT gf180mcu_fd_sc_mcu7t5v0__nor2_1 VSS VDD A2 A1 ZN \$8 SUB
M$1 \$7 A2 VDD \$8 pfet_05v0 L=0.5U W=1.22U AS=0.5368P AD=0.4087P PS=3.32U
+ PD=1.89U
M$2 ZN A1 \$7 \$8 pfet_05v0 L=0.5U W=1.22U AS=0.4087P AD=0.5368P PS=1.89U
+ PD=3.32U
M$3 ZN A2 VSS SUB nfet_05v0 L=0.6U W=0.565U AS=0.2486P AD=0.1469P PS=2.01U
+ PD=1.085U
M$4 VSS A1 ZN SUB nfet_05v0 L=0.6U W=0.565U AS=0.1469P AD=0.2486P PS=1.085U
+ PD=2.01U
.ENDS gf180mcu_fd_sc_mcu7t5v0__nor2_1

.SUBCKT gf180mcu_fd_sc_mcu7t5v0__dffrnq_1 VSS RN Q CLK D VDD \$20 SUB
M$1 \$10 \$9 VDD \$20 pfet_05v0 L=0.5U W=0.505U AS=0.2222P AD=0.2424P PS=1.89U
+ PD=1.465U
M$2 \$11 \$4 \$10 \$20 pfet_05v0 L=0.5U W=0.505U AS=0.2424P AD=0.2537625P
+ PS=1.465U PD=1.51U
M$3 \$12 \$8 \$11 \$20 pfet_05v0 L=0.5U W=0.505U AS=0.2537625P AD=0.1313P
+ PS=1.51U PD=1.025U
M$4 \$12 \$13 VDD \$20 pfet_05v0 L=0.5U W=0.505U AS=0.29465P AD=0.1313P
+ PS=1.74U PD=1.025U
M$5 \$13 RN VDD \$20 pfet_05v0 L=0.5U W=1U AS=0.29465P AD=0.26P PS=1.74U
+ PD=1.52U
M$6 VDD \$11 \$13 \$20 pfet_05v0 L=0.5U W=1U AS=0.26P AD=0.44P PS=1.52U PD=2.88U
M$7 VDD CLK \$4 \$20 pfet_05v0 L=0.5U W=0.865U AS=0.3806P AD=0.2249P PS=2.61U
+ PD=1.385U
M$8 \$8 \$4 VDD \$20 pfet_05v0 L=0.5U W=0.865U AS=0.2249P AD=0.3806P PS=1.385U
+ PD=2.61U
M$9 \$7 D VDD \$20 pfet_05v0 L=0.5U W=0.78U AS=0.3432P AD=0.2028P PS=2.44U
+ PD=1.3U
M$10 \$9 \$8 \$7 \$20 pfet_05v0 L=0.5U W=0.78U AS=0.2028P AD=0.2028P PS=1.3U
+ PD=1.3U
M$11 \$19 \$4 \$9 \$20 pfet_05v0 L=0.5U W=0.78U AS=0.2028P AD=0.2028P PS=1.3U
+ PD=1.3U
M$12 VDD \$10 \$19 \$20 pfet_05v0 L=0.5U W=0.78U AS=0.2028P AD=0.45P PS=1.3U
+ PD=2.02U
M$13 \$19 RN VDD \$20 pfet_05v0 L=0.5U W=0.78U AS=0.45P AD=0.3432P PS=2.02U
+ PD=2.44U
M$14 Q \$13 VDD \$20 pfet_05v0 L=0.5U W=1.215U AS=0.5346P AD=0.5346P PS=3.31U
+ PD=3.31U
M$15 \$7 D VSS SUB nfet_05v0 L=0.6U W=0.36U AS=0.1584P AD=0.0936P PS=1.6U
+ PD=0.88U
M$16 \$9 \$4 \$7 SUB nfet_05v0 L=0.6U W=0.36U AS=0.0936P AD=0.0936P PS=0.88U
+ PD=0.88U
M$17 \$16 \$8 \$9 SUB nfet_05v0 L=0.6U W=0.36U AS=0.0936P AD=0.0432P PS=0.88U
+ PD=0.6U
M$18 \$17 \$10 \$16 SUB nfet_05v0 L=0.6U W=0.36U AS=0.0432P AD=0.0432P PS=0.6U
+ PD=0.6U
M$19 \$17 RN VSS SUB nfet_05v0 L=0.6U W=0.36U AS=0.2016P AD=0.0432P PS=1.48U
+ PD=0.6U
M$20 \$10 \$9 VSS SUB nfet_05v0 L=0.6U W=0.36U AS=0.2016P AD=0.2007P PS=1.48U
+ PD=1.475U
M$21 \$11 \$8 \$10 SUB nfet_05v0 L=0.6U W=0.36U AS=0.2007P AD=0.2007P PS=1.475U
+ PD=1.475U
M$22 \$12 \$4 \$11 SUB nfet_05v0 L=0.6U W=0.36U AS=0.2007P AD=0.0945P PS=1.475U
+ PD=0.885U
M$23 VSS \$13 \$12 SUB nfet_05v0 L=0.6U W=0.36U AS=0.0945P AD=0.1224P PS=0.885U
+ PD=1.04U
M$24 VSS RN \$15 SUB nfet_05v0 L=0.6U W=0.36U AS=0.134P AD=0.1224P PS=1.1U
+ PD=1.04U
M$25 \$13 \$11 \$15 SUB nfet_05v0 L=0.6U W=0.4U AS=0.134P AD=0.176P PS=1.1U
+ PD=1.68U
M$26 Q \$13 VSS SUB nfet_05v0 L=0.6U W=0.815U AS=0.3586P AD=0.3586P PS=2.51U
+ PD=2.51U
M$27 VSS CLK \$4 SUB nfet_05v0 L=0.6U W=0.405U AS=0.1782P AD=0.1053P PS=1.69U
+ PD=0.925U
M$28 \$8 \$4 VSS SUB nfet_05v0 L=0.6U W=0.405U AS=0.1053P AD=0.1782P PS=0.925U
+ PD=1.69U
.ENDS gf180mcu_fd_sc_mcu7t5v0__dffrnq_1

.SUBCKT gf180mcu_fd_sc_mcu7t5v0__dlyb_1 I VDD VSS Z \$13 SUB
M$1 \$12 \$5 \$6 \$13 pfet_05v0 L=0.5U W=0.36U AS=0.3456P AD=0.0612P PS=2.64U
+ PD=0.7U
M$2 \$12 \$5 VDD \$13 pfet_05v0 L=0.5U W=0.36U AS=0.379P AD=0.0612P PS=2.37U
+ PD=0.7U
M$3 Z \$6 VDD \$13 pfet_05v0 L=0.5U W=1.22U AS=0.379P AD=0.5368P PS=2.37U
+ PD=3.32U
M$4 VDD I \$1 \$13 pfet_05v0 L=0.5U W=0.36U AS=0.3852P AD=0.1116P PS=2.86U
+ PD=0.98U
M$5 \$11 \$1 VDD \$13 pfet_05v0 L=0.5U W=0.36U AS=0.1116P AD=0.0612P PS=0.98U
+ PD=0.7U
M$6 \$11 \$1 \$5 \$13 pfet_05v0 L=0.5U W=0.36U AS=0.3852P AD=0.0612P PS=2.86U
+ PD=0.7U
M$7 \$10 \$5 \$6 SUB nfet_05v0 L=0.6U W=0.365U AS=0.3705P AD=0.0438P PS=2.77U
+ PD=0.605U
M$8 VSS \$5 \$10 SUB nfet_05v0 L=0.6U W=0.365U AS=0.0438P AD=0.282625P
+ PS=0.605U PD=1.87U
M$9 Z \$6 VSS SUB nfet_05v0 L=0.6U W=0.82U AS=0.282625P AD=0.3608P PS=1.87U
+ PD=2.52U
M$10 VSS I \$1 SUB nfet_05v0 L=0.6U W=0.36U AS=0.333P AD=0.0936P PS=2.57U
+ PD=0.88U
M$11 \$9 \$1 VSS SUB nfet_05v0 L=0.6U W=0.36U AS=0.0936P AD=0.0432P PS=0.88U
+ PD=0.6U
M$12 \$5 \$1 \$9 SUB nfet_05v0 L=0.6U W=0.36U AS=0.0432P AD=0.369P PS=0.6U
+ PD=2.77U
.ENDS gf180mcu_fd_sc_mcu7t5v0__dlyb_1

.SUBCKT B04_buffer_out VbiasN VbiasP VDD Venvelope Vinenvelope Vbpf Vinbpf GND
X$1 \$8 VbiasN VDD \$10 \$4 \$3 VbiasP GND B04_OTA_bias_ratio_5
X$2 \$4 \$3 Venvelope VDD Venvelope Vinenvelope \$8 \$10 GND B04_OTA
X$3 \$4 \$3 Vbpf VDD Vbpf Vinbpf \$8 \$10 GND B04_OTA
.ENDS B04_buffer_out

.SUBCKT B04_comparator VBIASP Q_BAR INN INP VDD GND
M$1 \$4 VBIASP VDD VDD pfet_03v3 L=4U W=2U AS=0.88P AD=0.88P PS=4.88U PD=4.88U
M$2 VDD \$11 \$14 VDD pfet_03v3 L=0.28U W=3.5U AS=1.5179P AD=1.5179P PS=7.88U
+ PD=7.88U
M$3 \$11 \$14 VDD VDD pfet_03v3 L=0.28U W=3.5U AS=1.5179P AD=1.5179P PS=7.88U
+ PD=7.88U
M$4 \$3 \$11 VDD VDD pfet_03v3 L=0.28U W=1.5U AS=0.6509P AD=0.6509P PS=3.88U
+ PD=3.88U
M$5 \$14 \$14 VDD VDD pfet_03v3 L=0.28U W=1.5U AS=0.6509P AD=0.6509P PS=3.88U
+ PD=3.88U
M$6 VDD \$14 Q_BAR VDD pfet_03v3 L=0.28U W=1.5U AS=0.6509P AD=0.6509P PS=3.88U
+ PD=3.88U
M$7 VDD \$11 \$11 VDD pfet_03v3 L=0.28U W=1.5U AS=0.6509P AD=0.6509P PS=3.88U
+ PD=3.88U
M$8 \$14 INP \$5 GND nfet_03v3 L=0.28U W=2U AS=0.86765P AD=0.86765P PS=4.88U
+ PD=4.88U
M$9 \$5 INN \$11 GND nfet_03v3 L=0.28U W=2U AS=0.86765P AD=0.86765P PS=4.88U
+ PD=4.88U
M$10 \$4 \$4 GND GND nfet_03v3 L=0.56U W=1U AS=0.44P AD=0.44P PS=2.88U PD=2.88U
M$11 \$5 \$4 GND GND nfet_03v3 L=0.56U W=1U AS=0.44P AD=0.44P PS=2.88U PD=2.88U
M$12 Q_BAR \$3 GND GND nfet_03v3 L=0.56U W=1U AS=0.44P AD=0.44P PS=2.88U
+ PD=2.88U
M$13 \$3 \$3 GND GND nfet_03v3 L=0.56U W=1U AS=0.44P AD=0.44P PS=2.88U PD=2.88U
.ENDS B04_comparator

.SUBCKT B04_envelope Vout VbiasN VDD Vin GND
C$1 GND Vout 2e-11 cap_mim_2f0fF A=10000P P=4000U
M$101 Vout Vin VDD GND nfet_03v3 L=1U W=2U AS=0.88P AD=0.88P PS=4.88U PD=4.88U
M$102 \$202 VbiasN Vout GND nfet_03v3 L=4U W=0.5U AS=0.22P AD=0.22P PS=1.88U
+ PD=1.88U
M$103 \$187 VbiasN \$188 GND nfet_03v3 L=4U W=0.5U AS=0.22P AD=0.22P PS=1.88U
+ PD=1.88U
M$104 GND VbiasN \$188 GND nfet_03v3 L=4U W=0.5U AS=0.22P AD=0.22P PS=1.88U
+ PD=1.88U
M$105 \$202 VbiasN \$203 GND nfet_03v3 L=4U W=0.5U AS=0.22P AD=0.22P PS=1.88U
+ PD=1.88U
M$106 \$187 VbiasN \$203 GND nfet_03v3 L=4U W=0.5U AS=0.22P AD=0.22P PS=1.88U
+ PD=1.88U
.ENDS B04_envelope

.SUBCKT B04_BPF4 Cap0 Cap1 Cap2 VbiasN VDD05 VbiasP VDD Vout Vin GND
X$137 \$729 \$719 \$63 VDD VDD05 \$51 \$730 \$735 GND B04_OTA
X$138 \$748 \$737 Vout VDD \$739 \$51 \$738 \$747 GND B04_OTA
X$139 \$727 \$718 \$51 VDD \$51 VDD05 \$728 \$734 GND B04_OTA
X$140 \$725 \$717 \$51 VDD VDD05 \$795 \$726 \$733 GND B04_OTA
X$141 \$731 \$720 \$51 VDD \$63 VDD05 \$732 \$736 GND B04_OTA
X$316 \$726 VbiasN VDD \$725 \$733 \$717 VbiasP GND B04_OTA_bias_ratio_025
X$317 \$730 VbiasN VDD \$729 \$735 \$719 VbiasP GND B04_OTA_bias_ratio_04
X$318 \$732 VbiasN VDD \$731 \$736 \$720 VbiasP GND B04_OTA_bias_ratio_04
X$319 \$728 VbiasN VDD \$727 \$734 \$718 VbiasP GND B04_OTA_bias_ratio_025
X$320 \$738 VbiasN VDD \$747 \$748 \$737 VbiasP GND B04_OTA_bias_ratio_5
X$345 \$727 \$718 \$795 VDD \$795 VDD05 \$728 \$734 GND B04_OTA
X$346 \$731 \$720 \$795 VDD \$822 VDD05 \$732 \$736 GND B04_OTA
X$347 \$725 \$717 \$795 VDD VDD05 Vin \$726 \$733 GND B04_OTA
X$348 \$729 \$719 \$822 VDD VDD05 \$795 \$730 \$735 GND B04_OTA
C$1 GND GND 3.84e-11 cap_mim_2f0fF A=19200P P=7680U
C$30 \$52 \$51 8e-12 cap_mim_2f0fF A=4000P P=1600U
C$34 \$64 \$63 2e-12 cap_mim_2f0fF A=1000P P=400U
C$59 \$94 \$63 4e-12 cap_mim_2f0fF A=2000P P=800U
C$106 GND \$63 1e-11 cap_mim_2f0fF A=5000P P=2000U
C$128 GND \$51 1e-11 cap_mim_2f0fF A=5000P P=2000U
C$226 \$425 \$63 8e-12 cap_mim_2f0fF A=4000P P=1600U
C$248 \$460 \$51 4e-12 cap_mim_2f0fF A=2000P P=800U
C$297 \$560 \$51 2e-12 cap_mim_2f0fF A=1000P P=400U
C$328 \$739 VDD05 4e-12 cap_mim_2f0fF A=2000P P=800U
C$335 \$739 Vout 2e-13 cap_mim_2f0fF A=100P P=40U
C$387 \$834 \$795 2e-12 cap_mim_2f0fF A=1000P P=400U
C$390 \$842 \$822 8e-12 cap_mim_2f0fF A=4000P P=1600U
C$413 \$835 \$795 4e-12 cap_mim_2f0fF A=2000P P=800U
C$461 GND \$795 1e-11 cap_mim_2f0fF A=5000P P=2000U
C$484 GND \$822 1e-11 cap_mim_2f0fF A=5000P P=2000U
C$589 \$836 \$795 8e-12 cap_mim_2f0fF A=4000P P=1600U
C$608 \$841 \$822 4e-12 cap_mim_2f0fF A=2000P P=800U
C$654 \$839 \$822 2e-12 cap_mim_2f0fF A=1000P P=400U
M$694 Vout Vout \$739 \$739 pfet_03v3 L=4U W=0.5U AS=0.22P AD=0.22P PS=1.88U
+ PD=1.88U
M$695 Vout \$739 \$739 Vout pfet_03v3 L=4U W=0.5U AS=0.22P AD=0.22P PS=1.88U
+ PD=1.88U
M$696 GND Cap2 \$52 GND nfet_03v3 L=1U W=0.5U AS=0.22P AD=0.22P PS=1.88U
+ PD=1.88U
M$697 GND Cap0 \$64 GND nfet_03v3 L=1U W=0.5U AS=0.22P AD=0.22P PS=1.88U
+ PD=1.88U
M$698 GND Cap1 \$94 GND nfet_03v3 L=1U W=0.5U AS=0.22P AD=0.22P PS=1.88U
+ PD=1.88U
M$699 GND Cap2 \$425 GND nfet_03v3 L=1U W=0.5U AS=0.22P AD=0.22P PS=1.88U
+ PD=1.88U
M$700 GND Cap1 \$460 GND nfet_03v3 L=1U W=0.5U AS=0.22P AD=0.22P PS=1.88U
+ PD=1.88U
M$701 GND Cap0 \$560 GND nfet_03v3 L=1U W=0.5U AS=0.22P AD=0.22P PS=1.88U
+ PD=1.88U
M$702 GND Cap0 \$839 GND nfet_03v3 L=1U W=0.5U AS=0.22P AD=0.22P PS=1.88U
+ PD=1.88U
M$703 GND Cap0 \$834 GND nfet_03v3 L=1U W=0.5U AS=0.22P AD=0.22P PS=1.88U
+ PD=1.88U
M$704 GND Cap1 \$841 GND nfet_03v3 L=1U W=0.5U AS=0.22P AD=0.22P PS=1.88U
+ PD=1.88U
M$705 GND Cap1 \$835 GND nfet_03v3 L=1U W=0.5U AS=0.22P AD=0.22P PS=1.88U
+ PD=1.88U
M$706 GND Cap2 \$842 GND nfet_03v3 L=1U W=0.5U AS=0.22P AD=0.22P PS=1.88U
+ PD=1.88U
M$707 GND Cap2 \$836 GND nfet_03v3 L=1U W=0.5U AS=0.22P AD=0.22P PS=1.88U
+ PD=1.88U
.ENDS B04_BPF4

.SUBCKT B04_coupling Vin Vout VDD05
C$1 Vout Vin 4e-12 cap_mim_2f0fF A=2000P P=800U
M$21 VDD05 Vout Vout VDD05 pfet_03v3 L=4U W=0.5U AS=0.22P AD=0.22P PS=1.88U
+ PD=1.88U
M$22 VDD05 VDD05 Vout Vout pfet_03v3 L=4U W=0.5U AS=0.22P AD=0.22P PS=1.88U
+ PD=1.88U
.ENDS B04_coupling

.SUBCKT B04_LNAv2 Vin Vout VDD VbiasP GND
C$1 \$8 Vin 4e-12 cap_mim_2f0fF A=2000P P=800U
C$20 Vout \$8 2e-13 cap_mim_2f0fF A=100P P=40U
M$22 VDD VbiasP Vout VDD pfet_03v3 L=4U W=40U AS=17.6P AD=17.6P PS=115.2U
+ PD=115.2U
M$62 Vout Vout \$8 \$8 pfet_03v3 L=20U W=1U AS=0.44P AD=0.44P PS=2.88U PD=2.88U
M$63 Vout \$8 \$8 Vout pfet_03v3 L=20U W=1U AS=0.44P AD=0.44P PS=2.88U PD=2.88U
M$64 Vout \$8 GND GND nfet_03v3 L=1U W=400U AS=111.2P AD=111.2P PS=495.6U
+ PD=495.6U
.ENDS B04_LNAv2

.SUBCKT B04_BMR VbiasP VbiasN VDD GND
X$4 VbiasN \$61 VbiasN VbiasP VDD GND B04_diff_amp
C$1 VbiasN VbiasP 4e-12 cap_mim_2f0fF A=2000P P=800U
M$21 \$65 VbiasN GND GND nfet_03v3 L=1U W=20U AS=8.8P AD=8.8P PS=40.88U
+ PD=40.88U
R$22 GND \$27 GND 410000 ppolyf_u_1k L=820U W=2U
M$42 VbiasP \$65 VbiasN GND nfet_03v3 L=1U W=1U AS=0.44P AD=0.44P PS=2.88U
+ PD=2.88U
M$43 \$74 \$65 \$65 VDD pfet_03v3 L=40U W=0.5U AS=0.22P AD=0.22P PS=1.88U
+ PD=1.88U
M$44 VDD \$73 \$73 VDD pfet_03v3 L=40U W=0.5U AS=0.22P AD=0.22P PS=1.88U
+ PD=1.88U
M$45 \$74 \$74 \$73 VDD pfet_03v3 L=40U W=0.5U AS=0.22P AD=0.22P PS=1.88U
+ PD=1.88U
M$46 VDD VbiasP VbiasN VDD pfet_03v3 L=4U W=2U AS=0.88P AD=0.88P PS=5.76U
+ PD=5.76U
M$48 \$61 VbiasP VDD VDD pfet_03v3 L=4U W=2U AS=0.88P AD=0.88P PS=5.76U PD=5.76U
M$50 VDD VDD VDD VDD pfet_03v3 L=4U W=2U AS=0.88P AD=0.88P PS=5.76U PD=5.76U
M$52 GND VbiasN VbiasN GND nfet_03v3 L=4U W=10U AS=4.4P AD=4.4P PS=20.88U
+ PD=20.88U
M$53 GND GND GND GND nfet_03v3 L=4U W=20U AS=8.8P AD=8.8P PS=41.76U PD=41.76U
M$55 \$61 VbiasN \$27 GND nfet_03v3 L=4U W=40U AS=14P AD=14P PS=62.8U PD=62.8U
.ENDS B04_BMR

.SUBCKT B04_VDD05 VbiasP VbiasN VDD Vout GND
X$1 \$17 VbiasN VDD \$16 \$31 \$15 VbiasP GND B04_OTA_bias_ratio_5
X$3 \$31 \$15 Vout VDD Vout \$20 \$17 \$16 GND B04_OTA
R$1 GND GND GND 3750 ppolyf_u_1k L=30U W=8U
R$12 GND \$20 GND 300000 ppolyf_u_1k L=600U W=2U
R$43 VDD \$20 GND 300000 ppolyf_u_1k L=600U W=2U
.ENDS B04_VDD05

.SUBCKT B04_OTA_bias_ratio_04 Vbias3 VbiasN VDD Vbias1 Vbias0 Vbias2 VbiasP GND
M$1 Vbias2 VbiasP VDD VDD pfet_03v3 L=4U W=2U AS=0.88P AD=0.88P PS=4.88U
+ PD=4.88U
M$2 Vbias3 VbiasN GND GND nfet_03v3 L=4U W=4U AS=1.76P AD=1.76P PS=8.88U
+ PD=8.88U
M$3 \$9 Vbias1 GND GND nfet_03v3 L=4U W=1U AS=0.44P AD=0.44P PS=2.88U PD=2.88U
M$4 Vbias1 Vbias2 \$9 GND nfet_03v3 L=4U W=1U AS=0.44P AD=0.44P PS=2.88U
+ PD=2.88U
M$5 Vbias3 VDD Vbias0 GND nfet_03v3 L=4U W=10U AS=4.4P AD=4.4P PS=20.88U
+ PD=20.88U
M$6 Vbias0 Vbias3 \$13 VDD pfet_03v3 L=4U W=5U AS=2.2P AD=2.2P PS=10.88U
+ PD=10.88U
M$7 \$13 Vbias0 VDD VDD pfet_03v3 L=4U W=5U AS=2.2P AD=2.2P PS=10.88U PD=10.88U
M$8 Vbias1 GND Vbias2 VDD pfet_03v3 L=4U W=5U AS=2.2P AD=2.2P PS=10.88U
+ PD=10.88U
.ENDS B04_OTA_bias_ratio_04

.SUBCKT B04_OTA_bias_ratio_025 Vbias3 VbiasN VDD Vbias1 Vbias0 Vbias2 VbiasP GND
M$1 Vbias2 VbiasP VDD VDD pfet_03v3 L=4U W=1.25U AS=0.55P AD=0.55P PS=3.38U
+ PD=3.38U
M$2 Vbias3 VbiasN GND GND nfet_03v3 L=4U W=2.5U AS=1.1P AD=1.1P PS=5.88U
+ PD=5.88U
M$3 Vbias1 Vbias2 \$10 GND nfet_03v3 L=4U W=1U AS=0.44P AD=0.44P PS=2.88U
+ PD=2.88U
M$4 \$10 Vbias1 GND GND nfet_03v3 L=4U W=1U AS=0.44P AD=0.44P PS=2.88U PD=2.88U
M$5 Vbias3 VDD Vbias0 GND nfet_03v3 L=4U W=10U AS=4.4P AD=4.4P PS=20.88U
+ PD=20.88U
M$6 Vbias0 Vbias3 \$14 VDD pfet_03v3 L=4U W=5U AS=2.2P AD=2.2P PS=10.88U
+ PD=10.88U
M$7 \$14 Vbias0 VDD VDD pfet_03v3 L=4U W=5U AS=2.2P AD=2.2P PS=10.88U PD=10.88U
M$8 Vbias1 GND Vbias2 VDD pfet_03v3 L=4U W=5U AS=2.2P AD=2.2P PS=10.88U
+ PD=10.88U
.ENDS B04_OTA_bias_ratio_025

.SUBCKT B04_diff_amp Vbias V+ V\x2d Vo VDD GND
M$1 VDD \$7 \$7 VDD pfet_03v3 L=4U W=13U AS=5.72P AD=5.72P PS=27.76U PD=27.76U
M$3 VDD \$7 Vo VDD pfet_03v3 L=4U W=13U AS=5.72P AD=5.72P PS=27.76U PD=27.76U
M$5 VDD VDD VDD VDD pfet_03v3 L=4U W=13U AS=5.72P AD=5.72P PS=27.76U PD=27.76U
M$7 GND Vbias \$4 GND nfet_03v3 L=4U W=2.2U AS=0.968P AD=0.968P PS=5.28U
+ PD=5.28U
M$8 \$7 V+ \$4 GND nfet_03v3 L=4U W=1.1U AS=0.484P AD=0.484P PS=3.96U PD=3.96U
M$10 \$4 V\x2d Vo GND nfet_03v3 L=4U W=1.1U AS=0.484P AD=0.484P PS=3.96U
+ PD=3.96U
M$12 GND GND GND GND nfet_03v3 L=4U W=1.1U AS=0.484P AD=0.484P PS=3.96U PD=3.96U
.ENDS B04_diff_amp

.SUBCKT B04_OTA Vbias1 Vbias2 Vout VDD Vin\x2d Vin+ Vbias3 Vbias0 GND
M$1 \$16 Vbias0 VDD VDD pfet_03v3 L=4U W=5U AS=1.75P AD=1.75P PS=8.9U PD=8.9U
M$3 Vout Vbias3 \$19 VDD pfet_03v3 L=4U W=5U AS=2.2P AD=2.2P PS=11.76U PD=11.76U
M$5 VDD \$11 \$19 VDD pfet_03v3 L=4U W=5U AS=2.2P AD=2.2P PS=11.76U PD=11.76U
M$6 VDD \$11 \$21 VDD pfet_03v3 L=4U W=5U AS=2.2P AD=2.2P PS=11.76U PD=11.76U
M$9 \$21 Vbias3 \$11 VDD pfet_03v3 L=4U W=5U AS=2.2P AD=2.2P PS=11.76U PD=11.76U
M$11 VDD VDD VDD VDD pfet_03v3 L=4U W=10U AS=4.4P AD=4.4P PS=23.52U PD=23.52U
M$15 \$5 Vin\x2d \$16 VDD pfet_03v3 L=1U W=2U AS=0.61P AD=0.61P PS=4.94U
+ PD=4.94U
M$19 \$9 Vin+ \$16 VDD pfet_03v3 L=1U W=2U AS=0.61P AD=0.61P PS=4.94U PD=4.94U
M$23 \$3 Vin+ \$16 VDD pfet_03v3 L=1U W=2U AS=0.61P AD=0.61P PS=4.94U PD=4.94U
M$27 \$4 Vin\x2d \$16 VDD pfet_03v3 L=1U W=2U AS=0.61P AD=0.61P PS=4.94U
+ PD=4.94U
M$31 VDD VDD VDD VDD pfet_03v3 L=1U W=2U AS=0.88P AD=0.88P PS=7.52U PD=7.52U
M$35 \$2 Vbias2 \$5 GND nfet_03v3 L=1U W=2U AS=0.88P AD=0.88P PS=5.76U PD=5.76U
M$36 \$9 Vbias2 \$7 GND nfet_03v3 L=1U W=2U AS=0.88P AD=0.88P PS=5.76U PD=5.76U
M$37 GND GND GND GND nfet_03v3 L=1U W=4U AS=1.76P AD=1.76P PS=11.52U PD=11.52U
M$43 GND \$5 \$2 GND nfet_03v3 L=4U W=1U AS=0.44P AD=0.44P PS=3.76U PD=3.76U
M$44 \$3 Vbias1 GND GND nfet_03v3 L=4U W=1U AS=0.44P AD=0.44P PS=3.76U PD=3.76U
M$45 \$3 \$5 GND GND nfet_03v3 L=4U W=1U AS=0.44P AD=0.44P PS=3.76U PD=3.76U
M$46 GND \$9 \$4 GND nfet_03v3 L=4U W=1U AS=0.44P AD=0.44P PS=3.76U PD=3.76U
M$47 GND Vbias1 \$4 GND nfet_03v3 L=4U W=1U AS=0.44P AD=0.44P PS=3.76U PD=3.76U
M$48 \$7 \$9 GND GND nfet_03v3 L=4U W=1U AS=0.44P AD=0.44P PS=3.76U PD=3.76U
M$49 GND GND GND GND nfet_03v3 L=4U W=3U AS=1.32P AD=1.32P PS=11.28U PD=11.28U
M$52 \$3 Vbias2 \$11 GND nfet_03v3 L=4U W=1U AS=0.44P AD=0.44P PS=3.76U PD=3.76U
M$58 \$4 Vbias2 Vout GND nfet_03v3 L=4U W=1U AS=0.44P AD=0.44P PS=3.76U PD=3.76U
.ENDS B04_OTA

.SUBCKT B04_OTA_bias_ratio_5 Vbias3 VbiasN VDD Vbias0 Vbias1 Vbias2 VbiasP GND
M$1 Vbias2 VbiasP VDD VDD pfet_03v3 L=4U W=25U AS=11P AD=11P PS=50.88U PD=50.88U
M$2 Vbias3 VbiasN GND GND nfet_03v3 L=4U W=50U AS=22P AD=22P PS=100.88U
+ PD=100.88U
M$3 \$10 Vbias1 GND GND nfet_03v3 L=4U W=1U AS=0.44P AD=0.44P PS=2.88U PD=2.88U
M$4 Vbias1 Vbias2 \$10 GND nfet_03v3 L=4U W=1U AS=0.44P AD=0.44P PS=2.88U
+ PD=2.88U
M$5 Vbias3 VDD Vbias0 GND nfet_03v3 L=4U W=10U AS=4.4P AD=4.4P PS=20.88U
+ PD=20.88U
M$6 Vbias0 Vbias3 \$15 VDD pfet_03v3 L=4U W=5U AS=2.2P AD=2.2P PS=10.88U
+ PD=10.88U
M$7 \$15 Vbias0 VDD VDD pfet_03v3 L=4U W=5U AS=2.2P AD=2.2P PS=10.88U PD=10.88U
M$8 Vbias1 GND Vbias2 VDD pfet_03v3 L=4U W=5U AS=2.2P AD=2.2P PS=10.88U
+ PD=10.88U
.ENDS B04_OTA_bias_ratio_5
