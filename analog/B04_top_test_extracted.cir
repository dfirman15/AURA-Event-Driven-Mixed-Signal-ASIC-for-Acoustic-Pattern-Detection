* Extracted by KLayout with GF180MCU LVS runset on : 06/08/2026 19:49

.SUBCKT B04_top_test Vin\x2d Vin+ GND \$3.Vout
X$1 Vin\x2d Vin+ \$10 \$7 GND \$3 \$2 B04_LNA
X$8 \$2 \$I11 \$2 \$3 \$10 GND B04_diff_amp
C$1 \$3.Vout GND 2e-11 cap_mim_2f0fF A=10000P P=4000U
R$115 \$I1 GND GND 410000 ppolyf_u_1k L=820U W=2U
M$121 \$I1 \$2 \$I11 GND nfet_03v3 L=4U W=40U AS=17.6P AD=17.6P PS=83.52U
+ PD=83.52U
M$125 \$2 \$3 \$10 \$10 pfet_03v3 L=4U W=2U AS=0.88P AD=0.88P PS=4.88U PD=4.88U
M$126 \$I11 \$3 \$10 \$10 pfet_03v3 L=4U W=2U AS=0.88P AD=0.88P PS=4.88U
+ PD=4.88U
M$127 \$2 \$I13 \$3 GND nfet_03v3 L=1U W=1U AS=0.44P AD=0.44P PS=2.88U PD=2.88U
M$128 \$I13 \$2 GND GND nfet_03v3 L=10U W=1U AS=0.44P AD=0.44P PS=2.88U PD=2.88U
M$129 \$I12 \$I14 \$I14 \$10 pfet_03v3 L=40U W=0.5U AS=0.22P AD=0.22P PS=1.88U
+ PD=1.88U
M$130 \$I12 \$I12 \$10 \$10 pfet_03v3 L=40U W=0.5U AS=0.22P AD=0.22P PS=1.88U
+ PD=1.88U
M$131 \$I13 \$I14 \$I14 \$10 pfet_03v3 L=40U W=0.5U AS=0.22P AD=0.22P PS=1.88U
+ PD=1.88U
M$132 \$I140 \$I140 \$10 \$10 pfet_03v3 L=5U W=1U AS=0.44P AD=0.44P PS=2.88U
+ PD=2.88U
M$133 \$I139 \$I139 \$I141 \$I141 pfet_03v3 L=5U W=1U AS=0.44P AD=0.44P
+ PS=2.88U PD=2.88U
M$134 \$I148 \$I148 \$I140 \$I140 pfet_03v3 L=5U W=1U AS=0.44P AD=0.44P
+ PS=2.88U PD=2.88U
M$135 \$I141 \$I141 \$I148 \$I148 pfet_03v3 L=5U W=1U AS=0.44P AD=0.44P
+ PS=2.88U PD=2.88U
M$136 \$I139 \$I139 GND GND nfet_03v3 L=4U W=5U AS=1.48P AD=1.48P PS=8.96U
+ PD=8.96U
M$141 GND \$I139 \$3.Vout GND nfet_03v3 L=4U W=7U AS=3.08P AD=3.08P PS=14.88U
+ PD=14.88U
M$142 \$3.Vout \$7 \$10 GND nfet_03v3 L=1U W=2U AS=0.88P AD=0.88P PS=4.88U
+ PD=4.88U
M$143 GND \$2 \$2 GND nfet_03v3 L=4U W=10U AS=4.4P AD=4.4P PS=20.88U PD=20.88U
.ENDS B04_top_test

.SUBCKT B04_diff_amp Vbias V+ V\x2d Vo VDD VSS
M$1 VSS Vbias \$3 VSS nfet_03v3 L=4U W=2.2U AS=0.968P AD=0.968P PS=5.28U
+ PD=5.28U
M$2 \$3 V\x2d Vo VSS nfet_03v3 L=4U W=1.1U AS=0.484P AD=0.484P PS=3.08U PD=3.08U
M$3 \$3 V+ \$7 VSS nfet_03v3 L=4U W=1.1U AS=0.484P AD=0.484P PS=3.08U PD=3.08U
M$4 \$7 \$7 VDD VDD pfet_03v3 L=4U W=13U AS=5.72P AD=5.72P PS=26.88U PD=26.88U
M$5 Vo \$7 VDD VDD pfet_03v3 L=4U W=13U AS=5.72P AD=5.72P PS=26.88U PD=26.88U
.ENDS B04_diff_amp

.SUBCKT B04_LNA \$1 \$2 \$5 \$699 SUB \$I2893 \$I2892
X$21 \$1460 \$I2892 \$5 \$7 \$6 \$81 \$I2893 SUB B04_OTA_bias_ratio_8
X$22 \$6 \$81 \$699 \$5 \$8 \$1460 \$202 \$7 SUB B04_LNA_OTA
C$1 \$1 \$8 2e-12 cap_mim_2f0fF A=1000P P=400U
C$2 \$2 \$202 2e-12 cap_mim_2f0fF A=1000P P=400U
C$21 \$699 \$8 2e-13 cap_mim_2f0fF A=100P P=40U
C$22 \$326 \$202 2e-13 cap_mim_2f0fF A=100P P=40U
M$23 \$8 \$773 \$773 \$8 pfet_03v3 L=4U W=1U AS=0.44P AD=0.44P PS=2.88U PD=2.88U
M$24 \$202 \$458 \$458 \$202 pfet_03v3 L=4U W=1U AS=0.44P AD=0.44P PS=2.88U
+ PD=2.88U
M$25 \$326 \$458 \$458 \$326 pfet_03v3 L=4U W=1U AS=0.44P AD=0.44P PS=2.88U
+ PD=2.88U
M$26 \$699 \$773 \$773 \$699 pfet_03v3 L=4U W=1U AS=0.44P AD=0.44P PS=2.88U
+ PD=2.88U
.ENDS B04_LNA

.SUBCKT B04_LNA_OTA \$2 \$5 \$10 \$27 \$43 \$44 \$45 \$48 SUB
M$1 SUB \$2 \$3 SUB nfet_03v3 L=8U W=20U AS=5.92P AD=5.92P PS=29.92U PD=29.92U
M$6 \$4 \$2 SUB SUB nfet_03v3 L=8U W=20U AS=5.92P AD=5.92P PS=29.92U PD=29.92U
M$21 \$46 \$48 \$27 \$27 pfet_03v3 L=4U W=10U AS=3.5P AD=3.5P PS=16.4U PD=16.4U
M$23 \$9 \$44 \$41 \$27 pfet_03v3 L=8U W=10U AS=4.4P AD=4.4P PS=20.88U PD=20.88U
M$24 \$42 \$9 \$27 \$27 pfet_03v3 L=8U W=10U AS=4.4P AD=4.4P PS=20.88U PD=20.88U
M$25 \$27 \$9 \$41 \$27 pfet_03v3 L=8U W=10U AS=4.4P AD=4.4P PS=20.88U PD=20.88U
M$26 \$42 \$44 \$10 \$27 pfet_03v3 L=8U W=10U AS=4.4P AD=4.4P PS=20.88U
+ PD=20.88U
M$27 \$25 \$5 \$6 SUB nfet_03v3 L=2U W=4U AS=1.76P AD=1.76P PS=8.88U PD=8.88U
M$28 \$7 \$5 \$11 SUB nfet_03v3 L=2U W=4U AS=1.76P AD=1.76P PS=8.88U PD=8.88U
M$29 SUB \$25 \$3 SUB nfet_03v3 L=8U W=2U AS=0.88P AD=0.88P PS=4.88U PD=4.88U
M$30 \$3 \$5 \$10 SUB nfet_03v3 L=8U W=2U AS=0.88P AD=0.88P PS=4.88U PD=4.88U
M$31 \$9 \$5 \$4 SUB nfet_03v3 L=8U W=2U AS=0.88P AD=0.88P PS=4.88U PD=4.88U
M$32 \$4 \$11 SUB SUB nfet_03v3 L=8U W=2U AS=0.88P AD=0.88P PS=4.88U PD=4.88U
M$33 SUB \$25 \$6 SUB nfet_03v3 L=8U W=2U AS=0.88P AD=0.88P PS=4.88U PD=4.88U
M$34 \$7 \$11 SUB SUB nfet_03v3 L=8U W=2U AS=0.88P AD=0.88P PS=4.88U PD=4.88U
M$35 \$3 \$43 \$46 \$27 pfet_03v3 L=8U W=144U AS=43.2P AD=43.2P PS=181.4U
+ PD=181.4U
M$40 \$46 \$45 \$4 \$27 pfet_03v3 L=8U W=144U AS=43.2P AD=43.2P PS=181.4U
+ PD=181.4U
M$53 \$46 \$43 \$11 \$27 pfet_03v3 L=8U W=16U AS=7.04P AD=7.04P PS=32.88U
+ PD=32.88U
M$54 \$25 \$45 \$46 \$27 pfet_03v3 L=8U W=16U AS=7.04P AD=7.04P PS=32.88U
+ PD=32.88U
M$55 \$27 \$27 \$27 \$27 pfet_03v3 L=8U W=32U AS=14.08P AD=14.08P PS=65.76U
+ PD=65.76U
.ENDS B04_LNA_OTA

.SUBCKT B04_OTA_bias_ratio_8 Vbias3 VbiasN VDD Vbias0 Vbias1 Vbias2 VbiasP GND
M$1 Vbias2 VbiasP VDD VDD pfet_03v3 L=4U W=40U AS=17.6P AD=17.6P PS=80.88U
+ PD=80.88U
M$2 Vbias3 VbiasN GND GND nfet_03v3 L=4U W=80U AS=35.2P AD=35.2P PS=160.88U
+ PD=160.88U
M$3 \$10 Vbias1 GND GND nfet_03v3 L=4U W=1U AS=0.44P AD=0.44P PS=2.88U PD=2.88U
M$4 Vbias1 Vbias2 \$10 GND nfet_03v3 L=4U W=1U AS=0.44P AD=0.44P PS=2.88U
+ PD=2.88U
M$5 Vbias3 VDD Vbias0 GND nfet_03v3 L=4U W=10U AS=4.4P AD=4.4P PS=20.88U
+ PD=20.88U
M$6 Vbias0 Vbias3 \$15 VDD pfet_03v3 L=4U W=5U AS=2.2P AD=2.2P PS=10.88U
+ PD=10.88U
M$7 \$15 Vbias0 VDD VDD pfet_03v3 L=4U W=5U AS=2.2P AD=2.2P PS=10.88U PD=10.88U
M$8 Vbias1 GND Vbias2 VDD pfet_03v3 L=4U W=5U AS=2.2P AD=2.2P PS=10.88U
+ PD=10.88U
.ENDS B04_OTA_bias_ratio_8
