* Extracted by KLayout with GF180MCU LVS runset on : 01/08/2026 11:55

.SUBCKT B04_BMR GND VbiasN VbiasP VDD
X$4 GND VbiasN \$15 VbiasN VbiasP VDD B04_diff_amp
R$6 GND \$3 GND 410000 ppolyf_u_1k L=820U W=2U
M$21 \$3 VbiasN \$15 GND nfet_03v3 L=4U W=40U AS=17.6P AD=17.6P PS=83.52U
+ PD=83.52U
M$25 GND VbiasN VbiasN GND nfet_03v3 L=4U W=10U AS=4.4P AD=4.4P PS=20.88U
+ PD=20.88U
M$26 VbiasN VbiasP VDD VDD pfet_03v3 L=4U W=2U AS=0.88P AD=0.88P PS=4.88U
+ PD=4.88U
M$27 \$15 VbiasP VDD VDD pfet_03v3 L=4U W=2U AS=0.88P AD=0.88P PS=4.88U PD=4.88U
M$28 VbiasN \$17 VbiasP GND nfet_03v3 L=1U W=1U AS=0.44P AD=0.44P PS=2.88U
+ PD=2.88U
M$29 \$17 VbiasN GND GND nfet_03v3 L=10U W=1U AS=0.44P AD=0.44P PS=2.88U
+ PD=2.88U
M$30 \$17 \$18 \$18 VDD pfet_03v3 L=40U W=0.5U AS=0.22P AD=0.22P PS=1.88U
+ PD=1.88U
M$31 \$16 \$16 VDD VDD pfet_03v3 L=40U W=0.5U AS=0.22P AD=0.22P PS=1.88U
+ PD=1.88U
M$32 \$16 \$18 \$18 VDD pfet_03v3 L=40U W=0.5U AS=0.22P AD=0.22P PS=1.88U
+ PD=1.88U
.ENDS B04_BMR

.SUBCKT B04_diff_amp VSS Vbias V+ V\x2d Vo VDD
M$1 VSS Vbias \$3 VSS nfet_03v3 L=4U W=2.2U AS=0.968P AD=0.968P PS=5.28U
+ PD=5.28U
M$2 \$3 V\x2d Vo VSS nfet_03v3 L=4U W=1.1U AS=0.484P AD=0.484P PS=3.08U PD=3.08U
M$3 \$3 V+ \$7 VSS nfet_03v3 L=4U W=1.1U AS=0.484P AD=0.484P PS=3.08U PD=3.08U
M$4 \$7 \$7 VDD VDD pfet_03v3 L=4U W=13U AS=5.72P AD=5.72P PS=26.88U PD=26.88U
M$5 Vo \$7 VDD VDD pfet_03v3 L=4U W=13U AS=5.72P AD=5.72P PS=26.88U PD=26.88U
.ENDS B04_diff_amp
