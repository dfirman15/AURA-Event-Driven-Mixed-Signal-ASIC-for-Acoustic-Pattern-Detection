* Extracted by KLayout with GF180MCU LVS runset on : 09/08/2026 11:04

.SUBCKT B04_BMR VbiasN VbiasP VDD GND
X$4 \$15 VbiasN \$15 VbiasP VDD GND B04_diff_amp
R$1 GND \$3 GND 410000 ppolyf_u_1k L=820U W=2U
M$21 VbiasN VbiasP VDD VDD pfet_03v3 L=4U W=2U AS=0.7P AD=0.7P PS=4.4U PD=4.4U
M$23 VDD VbiasP \$15 VDD pfet_03v3 L=4U W=2U AS=0.88P AD=0.88P PS=5.76U PD=5.76U
M$25 VDD VDD VDD VDD pfet_03v3 L=4U W=2U AS=0.88P AD=0.88P PS=5.76U PD=5.76U
M$27 VbiasP \$20 \$15 GND nfet_03v3 L=1U W=1U AS=0.44P AD=0.44P PS=2.88U
+ PD=2.88U
M$28 \$29 \$29 \$20 VDD pfet_03v3 L=40U W=0.5U AS=0.22P AD=0.22P PS=1.88U
+ PD=1.88U
M$29 VDD \$28 \$28 VDD pfet_03v3 L=40U W=0.5U AS=0.22P AD=0.22P PS=1.88U
+ PD=1.88U
M$30 \$29 \$29 \$28 VDD pfet_03v3 L=40U W=0.5U AS=0.22P AD=0.22P PS=1.88U
+ PD=1.88U
M$31 \$20 \$15 GND GND nfet_03v3 L=10U W=1U AS=0.44P AD=0.44P PS=2.88U PD=2.88U
M$32 GND \$15 \$15 GND nfet_03v3 L=4U W=10U AS=4.4P AD=4.4P PS=20.88U PD=20.88U
M$33 GND GND GND GND nfet_03v3 L=4U W=20U AS=8.8P AD=8.8P PS=41.76U PD=41.76U
M$35 VbiasN \$15 \$3 GND nfet_03v3 L=4U W=40U AS=14P AD=14P PS=62.8U PD=62.8U
.ENDS B04_BMR

.SUBCKT B04_diff_amp Vbias V+ V\x2d Vo VDD GND
M$1 Vo \$7 VDD VDD pfet_03v3 L=4U W=13U AS=4.55P AD=4.55P PS=20.9U PD=20.9U
M$3 VDD \$7 \$7 VDD pfet_03v3 L=4U W=13U AS=5.72P AD=5.72P PS=27.76U PD=27.76U
M$5 VDD VDD VDD VDD pfet_03v3 L=4U W=13U AS=5.72P AD=5.72P PS=27.76U PD=27.76U
M$7 Vo V\x2d \$4 GND nfet_03v3 L=4U W=1.1U AS=0.385P AD=0.385P PS=3.05U PD=3.05U
M$9 GND Vbias \$4 GND nfet_03v3 L=4U W=2.2U AS=0.968P AD=0.968P PS=5.28U
+ PD=5.28U
M$10 \$7 V+ \$4 GND nfet_03v3 L=4U W=1.1U AS=0.484P AD=0.484P PS=3.96U PD=3.96U
M$12 GND GND GND GND nfet_03v3 L=4U W=1.1U AS=0.484P AD=0.484P PS=3.96U PD=3.96U
.ENDS B04_diff_amp
