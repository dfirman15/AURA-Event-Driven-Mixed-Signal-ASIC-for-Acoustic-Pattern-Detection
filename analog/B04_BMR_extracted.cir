* Extracted by KLayout with GF180MCU LVS runset on : 12/08/2026 17:12

.SUBCKT B04_BMR V\x2d|Vbias V+|VbiasN VDD VbiasP|Vo GND
M$1 VDD VDD VDD VDD pfet_03v3 L=4U W=15U AS=6.6P AD=6.6P PS=33.52U PD=33.52U
M$2 VDD \$15 \$15 VDD pfet_03v3 L=4U W=13U AS=5.72P AD=5.72P PS=27.76U PD=27.76U
M$3 VbiasP|Vo \$15 VDD VDD pfet_03v3 L=4U W=13U AS=4.55P AD=4.55P PS=20.9U
+ PD=20.9U
M$7 \$20 \$20 \$18 VDD pfet_03v3 L=40U W=0.5U AS=0.22P AD=0.22P PS=1.88U
+ PD=1.88U
M$9 VDD VbiasP|Vo V\x2d|Vbias VDD pfet_03v3 L=4U W=2U AS=0.88P AD=0.88P
+ PS=5.76U PD=5.76U
M$10 V+|VbiasN VbiasP|Vo VDD VDD pfet_03v3 L=4U W=2U AS=0.7P AD=0.7P PS=4.4U
+ PD=4.4U
M$14 \$20 \$20 \$22 VDD pfet_03v3 L=40U W=0.5U AS=0.22P AD=0.22P PS=1.88U
+ PD=1.88U
M$15 VDD \$22 \$22 VDD pfet_03v3 L=40U W=0.5U AS=0.22P AD=0.22P PS=1.88U
+ PD=1.88U
M$16 GND V\x2d|Vbias \$13 GND nfet_03v3 L=4U W=2.2U AS=0.968P AD=0.968P
+ PS=5.28U PD=5.28U
M$17 GND GND GND GND nfet_03v3 L=4U W=21.1U AS=9.284P AD=9.284P PS=45.72U
+ PD=45.72U
M$18 \$13 V+|VbiasN \$15 GND nfet_03v3 L=4U W=1.1U AS=0.484P AD=0.484P PS=3.96U
+ PD=3.96U
M$19 VbiasP|Vo V\x2d|Vbias \$13 GND nfet_03v3 L=4U W=1.1U AS=0.385P AD=0.385P
+ PS=3.05U PD=3.05U
M$24 V+|VbiasN V\x2d|Vbias \$1 GND nfet_03v3 L=4U W=40U AS=14P AD=14P PS=62.8U
+ PD=62.8U
M$26 GND V\x2d|Vbias V\x2d|Vbias GND nfet_03v3 L=4U W=10U AS=4.4P AD=4.4P
+ PS=20.88U PD=20.88U
M$30 \$18 V\x2d|Vbias GND GND nfet_03v3 L=10U W=1U AS=0.44P AD=0.44P PS=2.88U
+ PD=2.88U
M$31 VbiasP|Vo \$18 V\x2d|Vbias GND nfet_03v3 L=1U W=1U AS=0.44P AD=0.44P
+ PS=2.88U PD=2.88U
R$50 \$1 GND GND 410000 ppolyf_u_1k L=820U W=2U
.ENDS B04_BMR
