* SPICE3 file created from BPF4_flatten.ext - technology: gf180mcuD

X0 a_32994_n2430# a_32994_n2762# GND.t408 GND.t407 nfet_03v3 ad=0.22p pd=1.88u as=0.22p ps=1.88u w=0.5u l=4u
X1 GND.t643 GND.t644 cap_mim_2f0_m4m5_noshield c_width=10u c_length=10u
X2 a_696_3298# B04_OTA_bias_ratio_025_0.Vbias0 VDD.t167 VDD.t166 pfet_03v3 ad=0.65p pd=3.02u as=1.1p ps=5.88u w=2.5u l=4u
X3 VDD.t210 VDD.t209 VDD.t210 VDD.t205 pfet_03v3 ad=0.22p pd=1.88u as=0 ps=0 w=0.5u l=1u
X4 GND.t433 B04_OTA_4.Vbias1 a_34354_3630# GND.t432 nfet_03v3 ad=0.22p pd=1.88u as=0.22p ps=1.88u w=0.5u l=4u
X5 B04_OTA_4.Vin- GND.t204 cap_mim_2f0_m4m5_noshield c_width=10u c_length=10u
X6 B04_OTA_6.Vin- GND.t345 cap_mim_2f0_m4m5_noshield c_width=10u c_length=10u
X7 a_696_3298# VDD05.t82 a_2344_3630# VDD.t61 pfet_03v3 ad=0.13p pd=1.02u as=0.13p ps=1.02u w=0.5u l=1u
X8 B04_OTA_3.Vin- GND.t24 cap_mim_2f0_m4m5_noshield c_width=10u c_length=10u
X9 VDD.t370 VDD.t369 VDD.t370 VDD.t365 pfet_03v3 ad=0.22p pd=1.88u as=0 ps=0 w=0.5u l=1u
X10 GND.t809 GND.t810 cap_mim_2f0_m4m5_noshield c_width=10u c_length=10u
X11 GND.t661 GND.t662 cap_mim_2f0_m4m5_noshield c_width=10u c_length=10u
X12 a_26296_3298# a_26384_4366# VDD.t142 VDD.t133 pfet_03v3 ad=1.1p pd=5.88u as=1.1p ps=5.88u w=2.5u l=4u
X13 GND.t410 a_32994_n2762# a_33892_n4132# GND.t405 nfet_03v3 ad=0.22p pd=1.88u as=0.22p ps=1.88u w=0.5u l=4u
X14 B04_OTA_bias_ratio_04_0.Vbias0 B04_OTA_bias_ratio_04_0.Vbias3 a_27450_n10140# VDD.t138 pfet_03v3 ad=2.2p pd=10.88u as=2.2p ps=10.88u w=5u l=4u
X15 B04_OTA_3.Vin- GND.t48 cap_mim_2f0_m4m5_noshield c_width=10u c_length=10u
X16 B04_OTA_4.Vin- a_31752_n13750# cap_mim_2f0_m4m5_noshield c_width=10u c_length=10u
X17 GND.t693 GND.t694 cap_mim_2f0_m4m5_noshield c_width=10u c_length=10u
X18 B04_OTA_4.Vin- a_32752_n13750# cap_mim_2f0_m4m5_noshield c_width=10u c_length=10u
X19 GND.t990 GND.t989 GND.t990 GND.t978 nfet_03v3 ad=0.44p pd=2.88u as=0 ps=0 w=1u l=1u
X20 B04_OTA_4.Vin- GND.t202 cap_mim_2f0_m4m5_noshield c_width=10u c_length=10u
X21 GND.t499 GND.t500 cap_mim_2f0_m4m5_noshield c_width=10u c_length=10u
X22 B04_OTA_3.Vin- a_31752_6250# cap_mim_2f0_m4m5_noshield c_width=10u c_length=10u
X23 B04_OTA_7.Vin+ a_20752_6250# cap_mim_2f0_m4m5_noshield c_width=10u c_length=10u
X24 GND.t725 GND.t726 cap_mim_2f0_m4m5_noshield c_width=10u c_length=10u
X25 a_4956_n2762# B04_OTA_bias_ratio_025_0.Vbias3 B04_OTA_6.Vin- VDD.t150 pfet_03v3 ad=1.1p pd=5.88u as=1.1p ps=5.88u w=2.5u l=4u
X26 a_32994_n2762# B04_OTA_4.Vin- a_32706_n2762# VDD.t82 pfet_03v3 ad=0.13p pd=1.02u as=0.13p ps=1.02u w=0.5u l=1u
X27 a_984_n2762# B04_OTA_bias_ratio_025_0.Vbias2 a_1882_n4132# GND.t238 nfet_03v3 ad=0.44p pd=2.88u as=0.44p ps=2.88u w=1u l=1u
X28 a_33892_n4132# a_32994_n2762# GND.t409 GND.t407 nfet_03v3 ad=0.22p pd=1.88u as=0.22p ps=1.88u w=0.5u l=4u
X29 B04_OTA_7.Vin+ GND.t98 cap_mim_2f0_m4m5_noshield c_width=10u c_length=10u
X30 GND.t747 GND.t748 cap_mim_2f0_m4m5_noshield c_width=10u c_length=10u
X31 B04_OTA_4.Vin- a_31752_n13750# cap_mim_2f0_m4m5_noshield c_width=10u c_length=10u
X32 GND.t767 GND.t768 cap_mim_2f0_m4m5_noshield c_width=10u c_length=10u
X33 a_48346_n2762# a_48434_n1694# VDD.t194 VDD.t189 pfet_03v3 ad=1.1p pd=5.88u as=1.1p ps=5.88u w=2.5u l=4u
X34 B04_OTA_6.Vin- GND.t349 cap_mim_2f0_m4m5_noshield c_width=10u c_length=10u
X35 B04_OTA_6.Vin- a_20752_n13750# cap_mim_2f0_m4m5_noshield c_width=10u c_length=10u
X36 GND.t639 GND.t640 cap_mim_2f0_m4m5_noshield c_width=10u c_length=10u
X37 GND.t898 GND.t897 GND.t898 GND.t893 nfet_03v3 ad=0.22p pd=1.88u as=0 ps=0 w=0.5u l=4u
X38 a_22324_n2762# VDD05.t31 a_22036_n2762# VDD.t76 pfet_03v3 ad=0.13p pd=1.02u as=0.22p ps=1.88u w=0.5u l=1u
X39 B04_OTA_7.Vin+ a_21752_6250# cap_mim_2f0_m4m5_noshield c_width=10u c_length=10u
X40 GND.t843 GND.t844 cap_mim_2f0_m4m5_noshield c_width=10u c_length=10u
X41 B04_OTA_4.Vin- a_32752_n13750# cap_mim_2f0_m4m5_noshield c_width=10u c_length=10u
X42 GND.t406 a_32994_n2762# a_32994_n2430# GND.t405 nfet_03v3 ad=0.22p pd=1.88u as=0.22p ps=1.88u w=0.5u l=4u
X43 GND.t283 VbiasN.t1 B04_OTA_4.Vbias3 GND.t282 nfet_03v3 ad=1.76p pd=8.88u as=1.76p ps=8.88u w=4u l=4u
X44 B04_OTA_7.Vin+ a_20752_6250# cap_mim_2f0_m4m5_noshield c_width=10u c_length=10u
X45 B04_OTA_6.Vin- a_21752_n13750# cap_mim_2f0_m4m5_noshield c_width=10u c_length=10u
X46 GND.t665 GND.t666 cap_mim_2f0_m4m5_noshield c_width=10u c_length=10u
X47 GND.t868 GND.t866 GND.t868 GND.t867 nfet_03v3 ad=0.22p pd=1.88u as=0 ps=0 w=0.5u l=4u
X48 GND.t176 a_12264_1516# a_12552_1516# GND.t175 nfet_03v3 ad=0.22p pd=1.88u as=0.22p ps=1.88u w=0.5u l=4u
X49 B04_OTA_3.Vin- GND.t22 cap_mim_2f0_m4m5_noshield c_width=10u c_length=10u
X50 B04_OTA_3.Vin- GND.t20 cap_mim_2f0_m4m5_noshield c_width=10u c_length=10u
X51 B04_OTA_6.Vin- a_21752_n13750# cap_mim_2f0_m4m5_noshield c_width=10u c_length=10u
X52 GND.t793 GND.t794 cap_mim_2f0_m4m5_noshield c_width=10u c_length=10u
X53 GND.t3 a_32994_3298# a_33892_1928# GND.t2 nfet_03v3 ad=0.22p pd=1.88u as=0.22p ps=1.88u w=0.5u l=4u
X54 B04_OTA_3.Vin- GND.t46 cap_mim_2f0_m4m5_noshield c_width=10u c_length=10u
X55 B04_OTA_3.Vin- a_32752_6250# cap_mim_2f0_m4m5_noshield c_width=10u c_length=10u
X56 a_23222_1928# B04_OTA_bias_ratio_04_0.Vbias2 a_22324_3298# GND.t56 nfet_03v3 ad=0.44p pd=2.88u as=0.44p ps=2.88u w=1u l=1u
X57 GND.t593 GND.t594 cap_mim_2f0_m4m5_noshield c_width=10u c_length=10u
X58 B04_OTA_7.Vin+ a_19752_6250# cap_mim_2f0_m4m5_noshield c_width=10u c_length=10u
X59 GND.t1042 GND.t1041 GND.t1042 GND.t1030 nfet_03v3 ad=0.44p pd=2.88u as=0 ps=0 w=1u l=1u
X60 VDD.t350 VDD.t349 VDD.t350 VDD.t345 pfet_03v3 ad=0.22p pd=1.88u as=0 ps=0 w=0.5u l=1u
X61 a_44374_n2430# B04_OTA_bias_ratio_5_0.Vbias2 a_48434_n1694# GND.t390 nfet_03v3 ad=0.22p pd=1.88u as=0.22p ps=1.88u w=0.5u l=4u
X62 GND.t495 GND.t496 cap_mim_2f0_m4m5_noshield c_width=10u c_length=10u
X63 a_2344_n2430# VDD05.t49 a_696_n2762# VDD.t46 pfet_03v3 ad=0.13p pd=1.02u as=0.13p ps=1.02u w=0.5u l=1u
X64 a_44374_n2430# B04_OTA_6.Vin- a_44086_n2762# VDD.t118 pfet_03v3 ad=0.13p pd=1.02u as=0.22p ps=1.88u w=0.5u l=1u
X65 a_13014_n2430# B04_OTA_bias_ratio_025_1.Vbias2 B04_OTA_6.Vin- GND.t261 nfet_03v3 ad=0.22p pd=1.88u as=0.22p ps=1.88u w=0.5u l=4u
X66 GND.t132 Cap1.t1 a_20752_n13750# GND.t131 nfet_03v3 ad=0.22p pd=1.88u as=0.22p ps=1.88u w=0.5u l=1u
X67 B04_OTA_7.Vin+ GND.t92 cap_mim_2f0_m4m5_noshield c_width=10u c_length=10u
X68 B04_OTA_7.Vin+ GND.t96 cap_mim_2f0_m4m5_noshield c_width=10u c_length=10u
X69 B04_OTA_6.Vin- a_20752_n13750# cap_mim_2f0_m4m5_noshield c_width=10u c_length=10u
X70 GND.t535 GND.t536 cap_mim_2f0_m4m5_noshield c_width=10u c_length=10u
X71 GND.t699 GND.t700 cap_mim_2f0_m4m5_noshield c_width=10u c_length=10u
X72 GND.t397 a_22324_n2762# a_23222_n4132# GND.t393 nfet_03v3 ad=0.22p pd=1.88u as=0.22p ps=1.88u w=0.5u l=4u
X73 B04_OTA_6.Vin- GND.t333 cap_mim_2f0_m4m5_noshield c_width=10u c_length=10u
X74 B04_OTA_7.Vin+ a_21752_6250# cap_mim_2f0_m4m5_noshield c_width=10u c_length=10u
X75 B04_OTA_7.Vin+ a_20752_6250# cap_mim_2f0_m4m5_noshield c_width=10u c_length=10u
X76 a_12264_1516# VDD05.t69 a_11366_3298# VDD.t26 pfet_03v3 ad=0.13p pd=1.02u as=0.13p ps=1.02u w=0.5u l=1u
X77 B04_OTA_3.Vin- a_32752_6250# cap_mim_2f0_m4m5_noshield c_width=10u c_length=10u
X78 a_36966_n2762# a_37054_n1694# VDD.t15 VDD.t14 pfet_03v3 ad=1.1p pd=5.88u as=1.1p ps=5.88u w=2.5u l=4u
X79 a_11366_3298# VDD05.t72 a_11654_3630# VDD.t31 pfet_03v3 ad=0.22p pd=1.88u as=0.13p ps=1.02u w=0.5u l=1u
X80 GND.t555 GND.t556 cap_mim_2f0_m4m5_noshield c_width=10u c_length=10u
X81 GND.t803 GND.t804 cap_mim_2f0_m4m5_noshield c_width=10u c_length=10u
X82 B04_OTA_4.Vin- a_32752_n13750# cap_mim_2f0_m4m5_noshield c_width=10u c_length=10u
X83 GND.t627 GND.t628 cap_mim_2f0_m4m5_noshield c_width=10u c_length=10u
X84 GND.t457 B04_OTA_bias_ratio_5_0.Vbias1 a_45734_n2430# GND.t456 nfet_03v3 ad=0.22p pd=1.88u as=0.22p ps=1.88u w=0.5u l=4u
X85 B04_OTA_3.Vin- a_32752_6250# cap_mim_2f0_m4m5_noshield c_width=10u c_length=10u
X86 B04_OTA_6.Vin- a_21752_n13750# cap_mim_2f0_m4m5_noshield c_width=10u c_length=10u
X87 GND.t287 VbiasN.t3 B04_OTA_bias_ratio_025_1.Vbias3 GND.t286 nfet_03v3 ad=1.1p pd=5.88u as=1.1p ps=5.88u w=2.5u l=4u
X88 B04_OTA_3.Vin- a_30752_6250# cap_mim_2f0_m4m5_noshield c_width=10u c_length=10u
X89 B04_OTA_4.Vin- GND.t207 cap_mim_2f0_m4m5_noshield c_width=10u c_length=10u
X90 B04_OTA_6.Vin- GND.t356 cap_mim_2f0_m4m5_noshield c_width=10u c_length=10u
X91 a_22036_3298# B04_OTA_7.Vin+ a_22934_1516# VDD.t39 pfet_03v3 ad=0.22p pd=1.88u as=0.13p ps=1.02u w=0.5u l=1u
X92 GND.t525 GND.t526 cap_mim_2f0_m4m5_noshield c_width=10u c_length=10u
X93 B04_OTA_7.Vin+ GND.t109 cap_mim_2f0_m4m5_noshield c_width=10u c_length=10u
X94 GND.t769 GND.t770 cap_mim_2f0_m4m5_noshield c_width=10u c_length=10u
X95 a_11366_n2762# B04_OTA_6.Vin- a_11654_n2762# VDD.t67 pfet_03v3 ad=0.22p pd=1.88u as=0.13p ps=1.02u w=0.5u l=1u
X96 GND.t394 a_22324_n2762# a_22324_n2430# GND.t393 nfet_03v3 ad=0.22p pd=1.88u as=0.22p ps=1.88u w=0.5u l=4u
X97 B04_OTA_4.Vin- a_31752_n13750# cap_mim_2f0_m4m5_noshield c_width=10u c_length=10u
X98 B04_OTA_4.Vin- a_32752_n13750# cap_mim_2f0_m4m5_noshield c_width=10u c_length=10u
X99 a_11654_3630# B04_OTA_bias_ratio_025_1.Vbias1 GND.t158 GND.t155 nfet_03v3 ad=0.22p pd=1.88u as=0.22p ps=1.88u w=0.5u l=4u
X100 a_49396_n2762# B04_OTA_bias_ratio_5_0.Vbias3 a_48434_n1694# VDD.t188 pfet_03v3 ad=1.1p pd=5.88u as=1.1p ps=5.88u w=2.5u l=4u
X101 B04_OTA_7.Vin+ a_21752_6250# cap_mim_2f0_m4m5_noshield c_width=10u c_length=10u
X102 GND.t781 GND.t782 cap_mim_2f0_m4m5_noshield c_width=10u c_length=10u
X103 a_11366_3298# B04_OTA_7.Vin+ a_11654_3298# VDD.t29 pfet_03v3 ad=0.13p pd=1.02u as=0.13p ps=1.02u w=0.5u l=1u
X104 B04_OTA_6.Vin- GND.t342 cap_mim_2f0_m4m5_noshield c_width=10u c_length=10u
X105 B04_OTA_4.Vin- a_32752_n13750# cap_mim_2f0_m4m5_noshield c_width=10u c_length=10u
X106 a_12552_1928# a_11654_3298# GND.t313 GND.t312 nfet_03v3 ad=0.22p pd=1.88u as=0.22p ps=1.88u w=0.5u l=4u
X107 a_15626_n2762# B04_OTA_bias_ratio_025_1.Vbias3 B04_OTA_6.Vin- VDD.t146 pfet_03v3 ad=1.1p pd=5.88u as=1.1p ps=5.88u w=2.5u l=4u
X108 GND.t483 GND.t484 cap_mim_2f0_m4m5_noshield c_width=10u c_length=10u
X109 B04_OTA_7.Vin+ a_20752_6250# cap_mim_2f0_m4m5_noshield c_width=10u c_length=10u
X110 GND.t823 GND.t824 cap_mim_2f0_m4m5_noshield c_width=10u c_length=10u
X111 a_11654_n2762# B04_OTA_bias_ratio_025_1.Vbias2 a_12552_n4132# GND.t257 nfet_03v3 ad=0.44p pd=2.88u as=0.44p ps=2.88u w=1u l=1u
X112 VDD.t123 a_15714_4366# a_16676_3298# VDD.t122 pfet_03v3 ad=1.1p pd=5.88u as=1.1p ps=5.88u w=2.5u l=4u
X113 VDD.t234 VDD.t233 VDD.t234 VDD.t219 pfet_03v3 ad=1.1p pd=5.88u as=0 ps=0 w=2.5u l=4u
X114 a_33604_1516# B04_OTA_4.Vbias2 a_33892_1516# GND.t270 nfet_03v3 ad=0.44p pd=2.88u as=0.44p ps=2.88u w=1u l=1u
X115 GND.t961 GND.t959 GND.t961 GND.t960 nfet_03v3 ad=0.22p pd=1.88u as=0 ps=0 w=0.5u l=4u
X116 GND.t458 B04_OTA_bias_ratio_5_0.Vbias1 a_44374_n2430# GND.t456 nfet_03v3 ad=0.22p pd=1.88u as=0.22p ps=1.88u w=0.5u l=4u
X117 GND.t140 Cap2.t0 a_32752_n13750# GND.t139 nfet_03v3 ad=0.22p pd=1.88u as=0.22p ps=1.88u w=0.5u l=1u
X118 GND.t811 GND.t812 cap_mim_2f0_m4m5_noshield c_width=10u c_length=10u
X119 VDD05.t19 B04_OTA_8.Vin- cap_mim_2f0_m4m5_noshield c_width=10u c_length=10u
X120 B04_OTA_6.Vin- a_21752_n13750# cap_mim_2f0_m4m5_noshield c_width=10u c_length=10u
X121 GND.t659 GND.t660 cap_mim_2f0_m4m5_noshield c_width=10u c_length=10u
X122 B04_OTA_3.Vin- a_32752_6250# cap_mim_2f0_m4m5_noshield c_width=10u c_length=10u
X123 B04_OTA_4.Vin- a_31752_n13750# cap_mim_2f0_m4m5_noshield c_width=10u c_length=10u
X124 a_1882_1928# B04_OTA_bias_ratio_025_0.Vbias2 a_984_3298# GND.t231 nfet_03v3 ad=0.44p pd=2.88u as=0.44p ps=2.88u w=1u l=1u
X125 B04_OTA_7.Vin+ a_21752_6250# cap_mim_2f0_m4m5_noshield c_width=10u c_length=10u
X126 B04_OTA_6.Vin- GND.t358 cap_mim_2f0_m4m5_noshield c_width=10u c_length=10u
X127 B04_OTA_4.Vin- a_32752_n13750# cap_mim_2f0_m4m5_noshield c_width=10u c_length=10u
X128 GND.t623 GND.t624 cap_mim_2f0_m4m5_noshield c_width=10u c_length=10u
X129 GND.t615 GND.t616 cap_mim_2f0_m4m5_noshield c_width=10u c_length=10u
X130 B04_OTA_6.Vin- GND.t371 cap_mim_2f0_m4m5_noshield c_width=10u c_length=10u
X131 B04_OTA_3.Vin- a_30752_6250# cap_mim_2f0_m4m5_noshield c_width=10u c_length=10u
X132 a_696_3298# VDD05.t80 a_2344_3630# VDD.t63 pfet_03v3 ad=0.22p pd=1.88u as=0.13p ps=1.02u w=0.5u l=1u
X133 a_11366_3298# B04_OTA_bias_ratio_025_1.Vbias0 VDD.t380 VDD.t379 pfet_03v3 ad=0.65p pd=3.02u as=1.1p ps=5.88u w=2.5u l=4u
X134 a_22324_3298# VDD05.t61 a_22036_3298# VDD.t34 pfet_03v3 ad=0.13p pd=1.02u as=0.13p ps=1.02u w=0.5u l=1u
X135 B04_OTA_3.Vin- a_31752_6250# cap_mim_2f0_m4m5_noshield c_width=10u c_length=10u
X136 B04_OTA_3.Vin- GND.t31 cap_mim_2f0_m4m5_noshield c_width=10u c_length=10u
X137 B04_OTA_7.Vin+ GND.t111 cap_mim_2f0_m4m5_noshield c_width=10u c_length=10u
X138 GND.t537 GND.t538 cap_mim_2f0_m4m5_noshield c_width=10u c_length=10u
X139 B04_OTA_7.Vin+ GND.t77 cap_mim_2f0_m4m5_noshield c_width=10u c_length=10u
X140 GND.t862 GND.t861 GND.t862 GND.t851 nfet_03v3 ad=0.44p pd=2.88u as=0 ps=0 w=1u l=1u
X141 GND.t719 GND.t720 cap_mim_2f0_m4m5_noshield c_width=10u c_length=10u
X142 GND.t679 GND.t680 cap_mim_2f0_m4m5_noshield c_width=10u c_length=10u
X143 B04_OTA_bias_ratio_025_0.Vbias1 GND.t1091 B04_OTA_bias_ratio_025_0.Vbias2 VDD.t101 pfet_03v3 ad=2.2p pd=10.88u as=2.2p ps=10.88u w=5u l=4u
X144 GND.t471 GND.t472 cap_mim_2f0_m4m5_noshield c_width=10u c_length=10u
X145 GND.t479 GND.t480 cap_mim_2f0_m4m5_noshield c_width=10u c_length=10u
X146 B04_OTA_6.Vin- a_21752_n13750# cap_mim_2f0_m4m5_noshield c_width=10u c_length=10u
X147 GND.t667 GND.t668 cap_mim_2f0_m4m5_noshield c_width=10u c_length=10u
X148 B04_OTA_7.Vin+ B04_OTA_4.Vbias2 a_34354_3630# GND.t271 nfet_03v3 ad=0.22p pd=1.88u as=0.22p ps=1.88u w=0.5u l=4u
X149 a_32994_n2762# B04_OTA_4.Vbias2 a_33892_n4132# GND.t276 nfet_03v3 ad=0.44p pd=2.88u as=0.44p ps=2.88u w=1u l=1u
X150 B04_OTA_6.Vin- a_21752_n13750# cap_mim_2f0_m4m5_noshield c_width=10u c_length=10u
X151 B04_OTA_4.Vin- GND.t210 cap_mim_2f0_m4m5_noshield c_width=10u c_length=10u
X152 a_696_3298# Vin.t2 a_1594_1516# VDD.t61 pfet_03v3 ad=0.13p pd=1.02u as=0.13p ps=1.02u w=0.5u l=1u
X153 GND.t573 GND.t574 cap_mim_2f0_m4m5_noshield c_width=10u c_length=10u
X154 a_44086_n2762# B04_OTA_bias_ratio_5_0.Vbias0 VDD.t177 VDD.t176 pfet_03v3 ad=0.65p pd=3.02u as=1.1p ps=5.88u w=2.5u l=4u
X155 B04_OTA_3.Vin- a_32752_6250# cap_mim_2f0_m4m5_noshield c_width=10u c_length=10u
X156 B04_OTA_4.Vin- GND.t181 cap_mim_2f0_m4m5_noshield c_width=10u c_length=10u
X157 B04_OTA_7.Vin+ a_21752_6250# cap_mim_2f0_m4m5_noshield c_width=10u c_length=10u
X158 VDD.t203 VDD.t201 VDD.t203 VDD.t202 pfet_03v3 ad=0.22p pd=1.88u as=0 ps=0 w=0.5u l=1u
X159 a_984_3630# B04_OTA_bias_ratio_025_0.Vbias1 GND.t297 GND.t295 nfet_03v3 ad=0.22p pd=1.88u as=0.22p ps=1.88u w=0.5u l=4u
X160 VDD.t294 VDD.t293 VDD.t294 VDD.t279 pfet_03v3 ad=1.1p pd=5.88u as=0 ps=0 w=2.5u l=4u
X161 a_5044_n1694# B04_OTA_bias_ratio_025_0.Vbias2 a_984_n2430# GND.t240 nfet_03v3 ad=0.22p pd=1.88u as=0.22p ps=1.88u w=0.5u l=4u
X162 B04_OTA_3.Vin- a_32752_6250# cap_mim_2f0_m4m5_noshield c_width=10u c_length=10u
X163 a_696_n2762# VDD05.t44 a_984_n2762# VDD.t43 pfet_03v3 ad=0.22p pd=1.88u as=0.13p ps=1.02u w=0.5u l=1u
X164 a_1882_1928# a_984_3298# GND.t1082 GND.t1081 nfet_03v3 ad=0.22p pd=1.88u as=0.22p ps=1.88u w=0.5u l=4u
X165 a_22036_n2762# B04_OTA_6.Vin- a_22324_n2430# VDD.t79 pfet_03v3 ad=0.22p pd=1.88u as=0.13p ps=1.02u w=0.5u l=1u
X166 VDD.t360 VDD.t358 VDD.t360 VDD.t359 pfet_03v3 ad=1.1p pd=5.88u as=0 ps=0 w=2.5u l=4u
X167 B04_OTA_3.Vin- a_31752_6250# cap_mim_2f0_m4m5_noshield c_width=10u c_length=10u
X168 B04_OTA_3.Vin- GND.t29 cap_mim_2f0_m4m5_noshield c_width=10u c_length=10u
X169 GND.t559 GND.t560 cap_mim_2f0_m4m5_noshield c_width=10u c_length=10u
X170 VDD.t263 VDD.t261 VDD.t263 VDD.t262 pfet_03v3 ad=0.22p pd=1.88u as=0 ps=0 w=0.5u l=1u
X171 a_12264_n4544# VDD05.t37 a_11366_n2762# VDD.t70 pfet_03v3 ad=0.13p pd=1.02u as=0.13p ps=1.02u w=0.5u l=1u
X172 VDD.t169 B04_OTA_bias_ratio_025_0.Vbias0 a_696_3298# VDD.t168 pfet_03v3 ad=1.1p pd=5.88u as=0.65p ps=3.02u w=2.5u l=4u
X173 a_22324_n2430# B04_OTA_bias_ratio_04_0.Vbias2 a_26384_n1694# GND.t66 nfet_03v3 ad=0.22p pd=1.88u as=0.22p ps=1.88u w=0.5u l=4u
X174 B04_OTA_4.Vin- a_32752_n13750# cap_mim_2f0_m4m5_noshield c_width=10u c_length=10u
X175 a_34354_3630# B04_OTA_3.Vin- a_32706_3298# VDD.t0 pfet_03v3 ad=0.13p pd=1.02u as=0.22p ps=1.88u w=0.5u l=1u
X176 B04_OTA_7.Vin+ GND.t115 cap_mim_2f0_m4m5_noshield c_width=10u c_length=10u
X177 B04_OTA_3.Vin- a_32752_6250# cap_mim_2f0_m4m5_noshield c_width=10u c_length=10u
X178 VDD05.t2 B04_OTA_8.Vin- cap_mim_2f0_m4m5_noshield c_width=10u c_length=10u
X179 a_34354_n2430# B04_OTA_4.Vin- a_32706_n2762# VDD.t86 pfet_03v3 ad=0.13p pd=1.02u as=0.13p ps=1.02u w=0.5u l=1u
X180 B04_OTA_6.Vin- a_20752_n13750# cap_mim_2f0_m4m5_noshield c_width=10u c_length=10u
X181 B04_OTA_4.Vin- a_31752_n13750# cap_mim_2f0_m4m5_noshield c_width=10u c_length=10u
X182 B04_OTA_4.Vin- a_32752_n13750# cap_mim_2f0_m4m5_noshield c_width=10u c_length=10u
X183 B04_OTA_7.Vin+ a_21752_6250# cap_mim_2f0_m4m5_noshield c_width=10u c_length=10u
X184 B04_OTA_3.Vin- a_32752_6250# cap_mim_2f0_m4m5_noshield c_width=10u c_length=10u
X185 GND.t173 a_22934_1516# a_23684_3630# GND.t169 nfet_03v3 ad=0.22p pd=1.88u as=0.22p ps=1.88u w=0.5u l=4u
X186 B04_OTA_bias_ratio_5_0.Vbias0 VDD.t390 B04_OTA_bias_ratio_5_0.Vbias3 GND.t415 nfet_03v3 ad=4.4p pd=20.88u as=4.4p ps=20.88u w=10u l=4u
X187 VDD05.t17 B04_OTA_8.Vin- cap_mim_2f0_m4m5_noshield c_width=10u c_length=10u
X188 a_23684_n2430# VDD05.t35 a_22036_n2762# VDD.t72 pfet_03v3 ad=0.13p pd=1.02u as=0.22p ps=1.88u w=0.5u l=1u
X189 B04_OTA_7.Vin+ a_19752_6250# cap_mim_2f0_m4m5_noshield c_width=10u c_length=10u
X190 B04_OTA_4.Vin- a_32752_n13750# cap_mim_2f0_m4m5_noshield c_width=10u c_length=10u
X191 B04_OTA_6.Vin- GND.t326 cap_mim_2f0_m4m5_noshield c_width=10u c_length=10u
X192 B04_OTA_3.Vin- GND.t14 cap_mim_2f0_m4m5_noshield c_width=10u c_length=10u
X193 B04_OTA_6.Vin- GND.t355 cap_mim_2f0_m4m5_noshield c_width=10u c_length=10u
X194 a_5044_4366# B04_OTA_bias_ratio_025_0.Vbias2 a_984_3630# GND.t234 nfet_03v3 ad=0.22p pd=1.88u as=0.22p ps=1.88u w=0.5u l=4u
X195 GND.t445 B04_OTA_bias_ratio_04_0.Vbias1 a_22324_3630# GND.t444 nfet_03v3 ad=0.22p pd=1.88u as=0.22p ps=1.88u w=0.5u l=4u
X196 GND.t936 GND.t934 GND.t936 GND.t935 nfet_03v3 ad=0.22p pd=1.88u as=0 ps=0 w=0.5u l=4u
X197 GND.t988 GND.t986 GND.t988 GND.t987 nfet_03v3 ad=0.22p pd=1.88u as=0 ps=0 w=0.5u l=4u
X198 B04_OTA_6.Vin- a_20752_n13750# cap_mim_2f0_m4m5_noshield c_width=10u c_length=10u
X199 B04_OTA_4.Vin- a_31752_n13750# cap_mim_2f0_m4m5_noshield c_width=10u c_length=10u
X200 a_5044_n1694# B04_OTA_bias_ratio_025_0.Vbias3 a_6006_n2762# VDD.t152 pfet_03v3 ad=1.1p pd=5.88u as=1.1p ps=5.88u w=2.5u l=4u
X201 B04_OTA_7.Vin+ GND.t90 cap_mim_2f0_m4m5_noshield c_width=10u c_length=10u
X202 GND.t721 GND.t722 cap_mim_2f0_m4m5_noshield c_width=10u c_length=10u
X203 B04_OTA_bias_ratio_04_0.Vbias1 B04_OTA_bias_ratio_04_0.Vbias2 a_24250_n11090# GND.t68 nfet_03v3 ad=0.44p pd=2.88u as=0.44p ps=2.88u w=1u l=4u
X204 B04_OTA_6.Vin- GND.t343 cap_mim_2f0_m4m5_noshield c_width=10u c_length=10u
X205 a_44086_n2762# B04_OTA_8.Vin- a_45734_n2430# VDD.t115 pfet_03v3 ad=0.13p pd=1.02u as=0.13p ps=1.02u w=0.5u l=1u
X206 B04_OTA_7.Vin+ GND.t113 cap_mim_2f0_m4m5_noshield c_width=10u c_length=10u
X207 a_27346_n2762# B04_OTA_bias_ratio_04_0.Vbias3 a_26384_n1694# VDD.t136 pfet_03v3 ad=1.1p pd=5.88u as=1.1p ps=5.88u w=2.5u l=4u
X208 B04_OTA_7.Vin+ GND.t88 cap_mim_2f0_m4m5_noshield c_width=10u c_length=10u
X209 B04_OTA_4.Vin- GND.t215 cap_mim_2f0_m4m5_noshield c_width=10u c_length=10u
X210 GND.t775 GND.t776 cap_mim_2f0_m4m5_noshield c_width=10u c_length=10u
X211 GND.t755 GND.t756 cap_mim_2f0_m4m5_noshield c_width=10u c_length=10u
X212 a_44374_n2430# B04_OTA_bias_ratio_5_0.Vbias1 GND.t461 GND.t459 nfet_03v3 ad=0.22p pd=1.88u as=0.22p ps=1.88u w=0.5u l=4u
X213 B04_OTA_6.Vin- GND.t328 cap_mim_2f0_m4m5_noshield c_width=10u c_length=10u
X214 B04_OTA_3.Vin- a_32752_6250# cap_mim_2f0_m4m5_noshield c_width=10u c_length=10u
X215 B04_OTA_6.Vin- GND.t359 cap_mim_2f0_m4m5_noshield c_width=10u c_length=10u
X216 GND.t607 GND.t608 cap_mim_2f0_m4m5_noshield c_width=10u c_length=10u
X217 a_11366_3298# B04_OTA_7.Vin+ a_11654_3298# VDD.t31 pfet_03v3 ad=0.22p pd=1.88u as=0.13p ps=1.02u w=0.5u l=1u
X218 a_22324_3630# B04_OTA_bias_ratio_04_0.Vbias2 a_26384_4366# GND.t60 nfet_03v3 ad=0.22p pd=1.88u as=0.22p ps=1.88u w=0.5u l=4u
X219 a_34354_3630# a_33604_1516# GND.t425 GND.t424 nfet_03v3 ad=0.22p pd=1.88u as=0.22p ps=1.88u w=0.5u l=4u
X220 B04_OTA_7.Vin+ a_19752_6250# cap_mim_2f0_m4m5_noshield c_width=10u c_length=10u
X221 GND.t517 GND.t518 cap_mim_2f0_m4m5_noshield c_width=10u c_length=10u
X222 B04_OTA_3.Vin- GND.t12 cap_mim_2f0_m4m5_noshield c_width=10u c_length=10u
X223 B04_OTA_4.Vin- GND.t213 cap_mim_2f0_m4m5_noshield c_width=10u c_length=10u
X224 a_1594_n4544# B04_OTA_7.Vin+ a_696_n2762# VDD.t46 pfet_03v3 ad=0.13p pd=1.02u as=0.13p ps=1.02u w=0.5u l=1u
X225 a_44374_n2762# B04_OTA_8.Vin- a_44086_n2762# VDD.t118 pfet_03v3 ad=0.13p pd=1.02u as=0.22p ps=1.88u w=0.5u l=1u
X226 GND.t561 GND.t562 cap_mim_2f0_m4m5_noshield c_width=10u c_length=10u
X227 B04_OTA_6.Vin- a_21752_n13750# cap_mim_2f0_m4m5_noshield c_width=10u c_length=10u
X228 a_696_n2762# B04_OTA_7.Vin+ a_984_n2430# VDD.t41 pfet_03v3 ad=0.13p pd=1.02u as=0.13p ps=1.02u w=0.5u l=1u
X229 B04_OTA_3.Vin- GND.t10 cap_mim_2f0_m4m5_noshield c_width=10u c_length=10u
X230 VDD.t314 VDD.t313 VDD.t314 VDD.t299 pfet_03v3 ad=1.1p pd=5.88u as=0 ps=0 w=2.5u l=4u
X231 B04_OTA_4.Vin- GND.t184 cap_mim_2f0_m4m5_noshield c_width=10u c_length=10u
X232 GND.t907 GND.t905 GND.t907 GND.t906 nfet_03v3 ad=0.22p pd=1.88u as=0 ps=0 w=0.5u l=4u
X233 a_15714_n1694# B04_OTA_bias_ratio_025_1.Vbias2 a_11654_n2430# GND.t259 nfet_03v3 ad=0.22p pd=1.88u as=0.22p ps=1.88u w=0.5u l=4u
X234 B04_OTA_7.Vin+ a_20752_6250# cap_mim_2f0_m4m5_noshield c_width=10u c_length=10u
X235 a_12552_n4132# B04_OTA_bias_ratio_025_1.Vbias2 a_11654_n2762# GND.t256 nfet_03v3 ad=0.44p pd=2.88u as=0.44p ps=2.88u w=1u l=1u
X236 a_45734_n2430# B04_OTA_bias_ratio_5_0.Vbias1 GND.t460 GND.t459 nfet_03v3 ad=0.22p pd=1.88u as=0.22p ps=1.88u w=0.5u l=4u
X237 GND.t463 GND.t464 cap_mim_2f0_m4m5_noshield c_width=10u c_length=10u
X238 B04_OTA_4.Vin- a_32752_n13750# cap_mim_2f0_m4m5_noshield c_width=10u c_length=10u
X239 VDD.t223 VDD.t221 VDD.t223 VDD.t222 pfet_03v3 ad=0.22p pd=1.88u as=0 ps=0 w=0.5u l=1u
X240 B04_OTA_7.Vin+ GND.t82 cap_mim_2f0_m4m5_noshield c_width=10u c_length=10u
X241 B04_OTA_7.Vin+ GND.t86 cap_mim_2f0_m4m5_noshield c_width=10u c_length=10u
X242 a_22324_3630# a_22324_3298# GND.t148 GND.t145 nfet_03v3 ad=0.22p pd=1.88u as=0.22p ps=1.88u w=0.5u l=4u
X243 B04_OTA_4.Vbias1 GND.t1088 B04_OTA_4.Vbias2 VDD.t113 pfet_03v3 ad=2.2p pd=10.88u as=2.2p ps=10.88u w=5u l=4u
X244 B04_OTA_4.Vin- GND.t182 cap_mim_2f0_m4m5_noshield c_width=10u c_length=10u
X245 a_11366_3298# B04_OTA_7.Vin+ a_13014_3630# VDD.t27 pfet_03v3 ad=0.22p pd=1.88u as=0.13p ps=1.02u w=0.5u l=1u
X246 GND.t917 GND.t915 GND.t917 GND.t916 nfet_03v3 ad=0.22p pd=1.88u as=0 ps=0 w=0.5u l=4u
X247 B04_OTA_3.Vin- GND.t17 cap_mim_2f0_m4m5_noshield c_width=10u c_length=10u
X248 GND.t709 GND.t710 cap_mim_2f0_m4m5_noshield c_width=10u c_length=10u
X249 GND.t611 GND.t612 cap_mim_2f0_m4m5_noshield c_width=10u c_length=10u
X250 GND.t419 a_44374_n2762# a_45272_n4132# GND.t418 nfet_03v3 ad=0.22p pd=1.88u as=0.22p ps=1.88u w=0.5u l=4u
X251 GND.t523 GND.t524 cap_mim_2f0_m4m5_noshield c_width=10u c_length=10u
X252 a_4956_n2762# a_5044_n1694# VDD.t151 VDD.t150 pfet_03v3 ad=1.1p pd=5.88u as=1.1p ps=5.88u w=2.5u l=4u
X253 B04_OTA_bias_ratio_04_0.Vbias2 VbiasP.t2 VDD.t157 VDD.t156 pfet_03v3 ad=0.88p pd=4.88u as=0.88p ps=4.88u w=2u l=4u
X254 B04_OTA_7.Vin+ GND.t69 cap_mim_2f0_m4m5_noshield c_width=10u c_length=10u
X255 B04_OTA_6.Vin- a_21752_n13750# cap_mim_2f0_m4m5_noshield c_width=10u c_length=10u
X256 B04_OTA_4.Vin- a_31752_n13750# cap_mim_2f0_m4m5_noshield c_width=10u c_length=10u
X257 B04_OTA_4.Vin- a_32752_n13750# cap_mim_2f0_m4m5_noshield c_width=10u c_length=10u
X258 B04_OTA_6.Vin- a_19752_n13750# cap_mim_2f0_m4m5_noshield c_width=10u c_length=10u
X259 a_696_3298# Vin.t0 a_1594_1516# VDD.t63 pfet_03v3 ad=0.22p pd=1.88u as=0.13p ps=1.02u w=0.5u l=1u
X260 GND.t1057 GND.t1055 GND.t1057 GND.t1056 nfet_03v3 ad=0.44p pd=2.88u as=0 ps=0 w=1u l=1u
X261 B04_OTA_4.Vin- a_32752_n13750# cap_mim_2f0_m4m5_noshield c_width=10u c_length=10u
X262 B04_OTA_7.Vin+ a_19752_6250# cap_mim_2f0_m4m5_noshield c_width=10u c_length=10u
X263 B04_OTA_6.Vin- a_21752_n13750# cap_mim_2f0_m4m5_noshield c_width=10u c_length=10u
X264 VDD05.t1 B04_OTA_8.Vin- cap_mim_2f0_m4m5_noshield c_width=10u c_length=10u
X265 B04_OTA_7.Vin+ B04_OTA_4.Vbias3 a_36966_3298# VDD.t48 pfet_03v3 ad=1.1p pd=5.88u as=1.1p ps=5.88u w=2.5u l=4u
X266 GND.t467 GND.t468 cap_mim_2f0_m4m5_noshield c_width=10u c_length=10u
X267 GND.t426 a_33604_1516# a_34354_3630# GND.t422 nfet_03v3 ad=0.22p pd=1.88u as=0.22p ps=1.88u w=0.5u l=4u
X268 B04_OTA_7.Vin+ GND.t94 cap_mim_2f0_m4m5_noshield c_width=10u c_length=10u
X269 GND.t777 GND.t778 cap_mim_2f0_m4m5_noshield c_width=10u c_length=10u
X270 B04_OTA_4.Vin- a_30752_n13750# cap_mim_2f0_m4m5_noshield c_width=10u c_length=10u
X271 B04_OTA_6.Vin- a_21752_n13750# cap_mim_2f0_m4m5_noshield c_width=10u c_length=10u
X272 a_15714_n1694# B04_OTA_bias_ratio_025_1.Vbias3 a_16676_n2762# VDD.t144 pfet_03v3 ad=1.1p pd=5.88u as=1.1p ps=5.88u w=2.5u l=4u
X273 B04_OTA_4.Vin- a_32752_n13750# cap_mim_2f0_m4m5_noshield c_width=10u c_length=10u
X274 B04_OTA_3.Vin- a_32752_6250# cap_mim_2f0_m4m5_noshield c_width=10u c_length=10u
X275 GND.t1080 GND.t1079 GND.t1080 GND.t1075 nfet_03v3 ad=0.22p pd=1.88u as=0 ps=0 w=0.5u l=4u
X276 B04_OTA_bias_ratio_025_1.Vbias1 B04_OTA_bias_ratio_025_1.Vbias2 a_13570_n11110# GND.t262 nfet_03v3 ad=0.44p pd=2.88u as=0.44p ps=2.88u w=1u l=4u
X277 GND.t629 GND.t630 cap_mim_2f0_m4m5_noshield c_width=10u c_length=10u
X278 GND.t434 B04_OTA_4.Vbias1 a_32994_3630# GND.t432 nfet_03v3 ad=0.22p pd=1.88u as=0.22p ps=1.88u w=0.5u l=4u
X279 a_984_n2430# B04_OTA_bias_ratio_025_0.Vbias2 a_5044_n1694# GND.t241 nfet_03v3 ad=0.22p pd=1.88u as=0.22p ps=1.88u w=0.5u l=4u
X280 GND.t420 a_44374_n2762# a_44374_n2430# GND.t418 nfet_03v3 ad=0.22p pd=1.88u as=0.22p ps=1.88u w=0.5u l=4u
X281 B04_OTA_3.Vin- GND.t44 cap_mim_2f0_m4m5_noshield c_width=10u c_length=10u
X282 B04_OTA_6.Vin- GND.t325 cap_mim_2f0_m4m5_noshield c_width=10u c_length=10u
X283 VDD.t382 B04_OTA_bias_ratio_025_1.Vbias0 a_11366_3298# VDD.t381 pfet_03v3 ad=1.1p pd=5.88u as=0.65p ps=3.02u w=2.5u l=4u
X284 B04_OTA_6.Vin- a_21752_n13750# cap_mim_2f0_m4m5_noshield c_width=10u c_length=10u
X285 B04_OTA_6.Vin- a_19752_n13750# cap_mim_2f0_m4m5_noshield c_width=10u c_length=10u
X286 VDD.t208 VDD.t207 VDD.t208 VDD.t202 pfet_03v3 ad=0.22p pd=1.88u as=0 ps=0 w=0.5u l=1u
X287 B04_OTA_3.Vin- a_32752_6250# cap_mim_2f0_m4m5_noshield c_width=10u c_length=10u
X288 B04_OTA_4.Vin- GND.t218 cap_mim_2f0_m4m5_noshield c_width=10u c_length=10u
X289 a_23684_n2430# B04_OTA_bias_ratio_04_0.Vbias2 B04_OTA_4.Vin- GND.t67 nfet_03v3 ad=0.22p pd=1.88u as=0.22p ps=1.88u w=0.5u l=4u
X290 GND.t974 GND.t972 GND.t974 GND.t973 nfet_03v3 ad=0.22p pd=1.88u as=0 ps=0 w=0.5u l=4u
X291 B04_OTA_7.Vin+ GND.t71 cap_mim_2f0_m4m5_noshield c_width=10u c_length=10u
X292 a_22324_3630# B04_OTA_7.Vin+ a_22036_3298# VDD.t32 pfet_03v3 ad=0.13p pd=1.02u as=0.22p ps=1.88u w=0.5u l=1u
X293 GND.t855 GND.t853 GND.t855 GND.t854 nfet_03v3 ad=0.22p pd=1.88u as=0 ps=0 w=0.5u l=4u
X294 a_1882_n4132# B04_OTA_bias_ratio_025_0.Vbias2 a_984_n2762# GND.t237 nfet_03v3 ad=0.44p pd=2.88u as=0.44p ps=2.88u w=1u l=1u
X295 B04_OTA_3.Vin- a_31752_6250# cap_mim_2f0_m4m5_noshield c_width=10u c_length=10u
X296 VDD.t268 VDD.t267 VDD.t268 VDD.t262 pfet_03v3 ad=0.22p pd=1.88u as=0 ps=0 w=0.5u l=1u
X297 a_2344_n2430# VDD05.t51 a_696_n2762# VDD.t44 pfet_03v3 ad=0.13p pd=1.02u as=0.22p ps=1.88u w=0.5u l=1u
X298 GND.t485 GND.t486 cap_mim_2f0_m4m5_noshield c_width=10u c_length=10u
X299 B04_OTA_7.Vin+ a_19752_6250# cap_mim_2f0_m4m5_noshield c_width=10u c_length=10u
X300 GND.t731 GND.t732 cap_mim_2f0_m4m5_noshield c_width=10u c_length=10u
X301 GND.t852 GND.t850 GND.t852 GND.t851 nfet_03v3 ad=0.44p pd=2.88u as=0 ps=0 w=1u l=1u
X302 GND.t1076 GND.t1074 GND.t1076 GND.t1075 nfet_03v3 ad=0.22p pd=1.88u as=0 ps=0 w=0.5u l=4u
X303 B04_OTA_4.Vin- GND.t216 cap_mim_2f0_m4m5_noshield c_width=10u c_length=10u
X304 a_33604_1516# VDD05.t55 a_32706_3298# VDD.t0 pfet_03v3 ad=0.13p pd=1.02u as=0.22p ps=1.88u w=0.5u l=1u
X305 GND.t571 GND.t572 cap_mim_2f0_m4m5_noshield c_width=10u c_length=10u
X306 B04_OTA_6.Vin- GND.t329 cap_mim_2f0_m4m5_noshield c_width=10u c_length=10u
X307 a_11366_n2762# VDD05.t42 a_11654_n2430# VDD.t65 pfet_03v3 ad=0.13p pd=1.02u as=0.13p ps=1.02u w=0.5u l=1u
X308 B04_OTA_7.Vin+ a_21752_6250# cap_mim_2f0_m4m5_noshield c_width=10u c_length=10u
X309 B04_OTA_3.Vin- a_32752_6250# cap_mim_2f0_m4m5_noshield c_width=10u c_length=10u
X310 a_32706_3298# VDD05.t58 a_32994_3630# VDD.t5 pfet_03v3 ad=0.13p pd=1.02u as=0.13p ps=1.02u w=0.5u l=1u
X311 a_15714_4366# B04_OTA_bias_ratio_025_1.Vbias2 a_11654_3630# GND.t253 nfet_03v3 ad=0.22p pd=1.88u as=0.22p ps=1.88u w=0.5u l=4u
X312 GND.t894 GND.t892 GND.t894 GND.t893 nfet_03v3 ad=0.22p pd=1.88u as=0 ps=0 w=0.5u l=4u
X313 GND.t1052 GND.t1051 GND.t1052 GND.t1046 nfet_03v3 ad=0.22p pd=1.88u as=0 ps=0 w=0.5u l=4u
X314 B04_OTA_4.Vin- a_31752_n13750# cap_mim_2f0_m4m5_noshield c_width=10u c_length=10u
X315 B04_OTA_bias_ratio_5_0.Vbias2 VbiasP.t0 VDD.t165 VDD.t164 pfet_03v3 ad=11p pd=50.88u as=11p ps=50.88u w=25u l=4u
X316 GND.t122 Cap0.t1 a_19752_n13750# GND.t121 nfet_03v3 ad=0.22p pd=1.88u as=0.22p ps=1.88u w=0.5u l=1u
X317 B04_OTA_4.Vin- GND.t187 cap_mim_2f0_m4m5_noshield c_width=10u c_length=10u
X318 B04_OTA_6.Vin- GND.t336 cap_mim_2f0_m4m5_noshield c_width=10u c_length=10u
X319 a_5044_4366# B04_OTA_bias_ratio_025_0.Vbias3 a_6006_3298# VDD.t20 pfet_03v3 ad=1.1p pd=5.88u as=1.1p ps=5.88u w=2.5u l=4u
X320 VDD.t274 VDD.t273 VDD.t274 VDD.t259 pfet_03v3 ad=1.1p pd=5.88u as=0 ps=0 w=2.5u l=4u
X321 VDD.t323 VDD.t321 VDD.t323 VDD.t322 pfet_03v3 ad=0.22p pd=1.88u as=0 ps=0 w=0.5u l=1u
X322 GND.t142 Cap2.t1 a_21752_n13750# GND.t141 nfet_03v3 ad=0.22p pd=1.88u as=0.22p ps=1.88u w=0.5u l=1u
X323 B04_OTA_3.Vin- GND.t42 cap_mim_2f0_m4m5_noshield c_width=10u c_length=10u
X324 GND.t968 GND.t966 GND.t968 GND.t967 nfet_03v3 ad=0.22p pd=1.88u as=0 ps=0 w=0.5u l=4u
X325 B04_OTA_4.Vin- GND.t221 cap_mim_2f0_m4m5_noshield c_width=10u c_length=10u
X326 a_6006_n2762# B04_OTA_bias_ratio_025_0.Vbias3 a_5044_n1694# VDD.t154 pfet_03v3 ad=1.1p pd=5.88u as=1.1p ps=5.88u w=2.5u l=4u
X327 GND.t982 GND.t980 GND.t982 GND.t981 nfet_03v3 ad=0.44p pd=2.88u as=0 ps=0 w=1u l=1u
X328 B04_OTA_3.Vin- GND.t40 cap_mim_2f0_m4m5_noshield c_width=10u c_length=10u
X329 GND.t4 a_32994_3298# a_32994_3630# GND.t2 nfet_03v3 ad=0.22p pd=1.88u as=0.22p ps=1.88u w=0.5u l=4u
X330 a_22036_n2762# VDD05.t28 a_22324_n2762# VDD.t79 pfet_03v3 ad=0.22p pd=1.88u as=0.13p ps=1.02u w=0.5u l=1u
X331 B04_OTA_3.Vin- a_32752_6250# cap_mim_2f0_m4m5_noshield c_width=10u c_length=10u
X332 B04_OTA_6.Vin- a_21752_n13750# cap_mim_2f0_m4m5_noshield c_width=10u c_length=10u
X333 GND.t619 GND.t620 cap_mim_2f0_m4m5_noshield c_width=10u c_length=10u
X334 VDD.t191 a_48434_n1694# a_49396_n2762# VDD.t188 pfet_03v3 ad=1.1p pd=5.88u as=1.1p ps=5.88u w=2.5u l=4u
X335 B04_OTA_3.Vin- a_31752_6250# cap_mim_2f0_m4m5_noshield c_width=10u c_length=10u
X336 a_26296_n2762# B04_OTA_bias_ratio_04_0.Vbias3 B04_OTA_4.Vin- VDD.t137 pfet_03v3 ad=1.1p pd=5.88u as=1.1p ps=5.88u w=2.5u l=4u
X337 B04_OTA_4.Vin- B04_OTA_bias_ratio_04_0.Vbias2 a_23684_n2430# GND.t64 nfet_03v3 ad=0.22p pd=1.88u as=0.22p ps=1.88u w=0.5u l=4u
X338 VDD.t266 VDD.t264 VDD.t266 VDD.t265 pfet_03v3 ad=0.22p pd=1.88u as=0 ps=0 w=0.5u l=1u
X339 a_15626_n2762# a_15714_n1694# VDD.t185 VDD.t146 pfet_03v3 ad=1.1p pd=5.88u as=1.1p ps=5.88u w=2.5u l=4u
X340 GND.t649 GND.t650 cap_mim_2f0_m4m5_noshield c_width=10u c_length=10u
X341 a_33604_n4544# VDD05.t21 a_32706_n2762# VDD.t86 pfet_03v3 ad=0.13p pd=1.02u as=0.13p ps=1.02u w=0.5u l=1u
X342 GND.t1047 GND.t1045 GND.t1047 GND.t1046 nfet_03v3 ad=0.22p pd=1.88u as=0 ps=0 w=0.5u l=4u
X343 GND.t551 GND.t552 cap_mim_2f0_m4m5_noshield c_width=10u c_length=10u
X344 B04_OTA_7.Vin+ GND.t75 cap_mim_2f0_m4m5_noshield c_width=10u c_length=10u
X345 B04_OTA_6.Vin- GND.t338 cap_mim_2f0_m4m5_noshield c_width=10u c_length=10u
X346 a_37054_4366# B04_OTA_4.Vbias2 a_32994_3630# GND.t272 nfet_03v3 ad=0.22p pd=1.88u as=0.22p ps=1.88u w=0.5u l=4u
X347 a_32706_n2762# VDD05.t26 a_32994_n2430# VDD.t81 pfet_03v3 ad=0.13p pd=1.02u as=0.13p ps=1.02u w=0.5u l=1u
X348 a_44086_n2762# B04_OTA_6.Vin- a_44374_n2430# VDD.t121 pfet_03v3 ad=0.22p pd=1.88u as=0.13p ps=1.02u w=0.5u l=1u
X349 B04_OTA_4.Vin- a_32752_n13750# cap_mim_2f0_m4m5_noshield c_width=10u c_length=10u
X350 VDD.t139 a_26384_4366# a_26296_3298# VDD.t130 pfet_03v3 ad=1.1p pd=5.88u as=1.1p ps=5.88u w=2.5u l=4u
X351 a_27346_3298# B04_OTA_bias_ratio_04_0.Vbias3 a_26384_4366# VDD.t132 pfet_03v3 ad=1.1p pd=5.88u as=1.1p ps=5.88u w=2.5u l=4u
X352 B04_OTA_6.Vin- GND.t351 cap_mim_2f0_m4m5_noshield c_width=10u c_length=10u
X353 a_22934_n4544# B04_OTA_6.Vin- a_22036_n2762# VDD.t72 pfet_03v3 ad=0.13p pd=1.02u as=0.22p ps=1.88u w=0.5u l=1u
X354 a_44984_n4544# B04_OTA_bias_ratio_5_0.Vbias2 a_45272_n4544# GND.t387 nfet_03v3 ad=0.44p pd=2.88u as=0.44p ps=2.88u w=1u l=1u
X355 a_48320_n8570# B04_OTA_bias_ratio_5_0.Vbias0 VDD.t181 VDD.t180 pfet_03v3 ad=2.2p pd=10.88u as=2.2p ps=10.88u w=5u l=4u
X356 GND.t475 GND.t476 cap_mim_2f0_m4m5_noshield c_width=10u c_length=10u
X357 B04_OTA_3.Vin- GND.t25 cap_mim_2f0_m4m5_noshield c_width=10u c_length=10u
X358 B04_OTA_3.Vin- GND.t51 cap_mim_2f0_m4m5_noshield c_width=10u c_length=10u
X359 B04_OTA_3.Vin- a_32752_6250# cap_mim_2f0_m4m5_noshield c_width=10u c_length=10u
X360 GND.t912 GND.t911 GND.t912 GND.t900 nfet_03v3 ad=0.44p pd=2.88u as=0 ps=0 w=1u l=1u
X361 B04_OTA_6.Vin- a_21752_n13750# cap_mim_2f0_m4m5_noshield c_width=10u c_length=10u
X362 B04_OTA_4.Vin- a_30752_n13750# cap_mim_2f0_m4m5_noshield c_width=10u c_length=10u
X363 GND.t505 GND.t506 cap_mim_2f0_m4m5_noshield c_width=10u c_length=10u
X364 B04_OTA_4.Vin- a_32752_n13750# cap_mim_2f0_m4m5_noshield c_width=10u c_length=10u
X365 GND.t703 GND.t704 cap_mim_2f0_m4m5_noshield c_width=10u c_length=10u
X366 VDD.t252 VDD.t251 VDD.t252 VDD.t236 pfet_03v3 ad=1.1p pd=5.88u as=0 ps=0 w=2.5u l=4u
X367 a_11654_n2430# B04_OTA_bias_ratio_025_1.Vbias2 a_15714_n1694# GND.t260 nfet_03v3 ad=0.22p pd=1.88u as=0.22p ps=1.88u w=0.5u l=4u
X368 B04_OTA_3.Vin- a_31752_6250# cap_mim_2f0_m4m5_noshield c_width=10u c_length=10u
X369 B04_OTA_7.Vin+ a_20752_6250# cap_mim_2f0_m4m5_noshield c_width=10u c_length=10u
X370 B04_OTA_4.Vin- GND.t190 cap_mim_2f0_m4m5_noshield c_width=10u c_length=10u
X371 a_12552_1516# a_12264_1516# GND.t178 GND.t177 nfet_03v3 ad=0.22p pd=1.88u as=0.22p ps=1.88u w=0.5u l=4u
X372 a_44086_n2762# B04_OTA_6.Vin- a_44984_n4544# VDD.t115 pfet_03v3 ad=0.13p pd=1.02u as=0.13p ps=1.02u w=0.5u l=1u
X373 B04_OTA_6.Vin- a_21752_n13750# cap_mim_2f0_m4m5_noshield c_width=10u c_length=10u
X374 VDD.t303 VDD.t301 VDD.t303 VDD.t302 pfet_03v3 ad=0.22p pd=1.88u as=0 ps=0 w=0.5u l=1u
X375 B04_OTA_4.Vin- a_30752_n13750# cap_mim_2f0_m4m5_noshield c_width=10u c_length=10u
X376 GND.t645 GND.t646 cap_mim_2f0_m4m5_noshield c_width=10u c_length=10u
X377 a_13014_3630# B04_OTA_bias_ratio_025_1.Vbias1 GND.t156 GND.t155 nfet_03v3 ad=0.22p pd=1.88u as=0.22p ps=1.88u w=0.5u l=4u
X378 B04_OTA_7.Vin+ GND.t80 cap_mim_2f0_m4m5_noshield c_width=10u c_length=10u
X379 GND.t765 GND.t766 cap_mim_2f0_m4m5_noshield c_width=10u c_length=10u
X380 B04_OTA_7.Vin+ GND.t73 cap_mim_2f0_m4m5_noshield c_width=10u c_length=10u
X381 B04_OTA_6.Vin- a_20752_n13750# cap_mim_2f0_m4m5_noshield c_width=10u c_length=10u
X382 GND.t641 GND.t642 cap_mim_2f0_m4m5_noshield c_width=10u c_length=10u
X383 VDD.t228 VDD.t227 VDD.t228 VDD.t222 pfet_03v3 ad=0.22p pd=1.88u as=0 ps=0 w=0.5u l=1u
X384 B04_OTA_4.Vin- B04_OTA_bias_ratio_04_0.Vbias3 a_26296_n2762# VDD.t134 pfet_03v3 ad=1.1p pd=5.88u as=1.1p ps=5.88u w=2.5u l=4u
X385 B04_OTA_7.Vin+ a_21752_6250# cap_mim_2f0_m4m5_noshield c_width=10u c_length=10u
X386 GND.t787 GND.t788 cap_mim_2f0_m4m5_noshield c_width=10u c_length=10u
X387 a_13014_n2430# B04_OTA_6.Vin- a_11366_n2762# VDD.t68 pfet_03v3 ad=0.13p pd=1.02u as=0.22p ps=1.88u w=0.5u l=1u
X388 a_44374_n2430# a_44374_n2762# GND.t421 GND.t416 nfet_03v3 ad=0.22p pd=1.88u as=0.22p ps=1.88u w=0.5u l=4u
X389 GND.t955 GND.t953 GND.t955 GND.t954 nfet_03v3 ad=0.44p pd=2.88u as=0 ps=0 w=1u l=1u
X390 GND.t515 GND.t516 cap_mim_2f0_m4m5_noshield c_width=10u c_length=10u
X391 B04_OTA_6.Vin- a_21752_n13750# cap_mim_2f0_m4m5_noshield c_width=10u c_length=10u
X392 VDD.t280 VDD.t278 VDD.t280 VDD.t279 pfet_03v3 ad=1.1p pd=5.88u as=0 ps=0 w=2.5u l=4u
X393 B04_OTA_3.Vin- GND.t23 cap_mim_2f0_m4m5_noshield c_width=10u c_length=10u
X394 B04_OTA_3.Vin- GND.t49 cap_mim_2f0_m4m5_noshield c_width=10u c_length=10u
X395 B04_OTA_6.Vin- GND.t364 cap_mim_2f0_m4m5_noshield c_width=10u c_length=10u
X396 Vout.t8 B04_OTA_8.Vin- cap_mim_2f0_m4m5_noshield c_width=10u c_length=10u
X397 a_11366_3298# VDD05.t68 a_12264_1516# VDD.t27 pfet_03v3 ad=0.22p pd=1.88u as=0.13p ps=1.02u w=0.5u l=1u
X398 B04_OTA_4.Vin- GND.t219 cap_mim_2f0_m4m5_noshield c_width=10u c_length=10u
X399 VDD.t240 VDD.t238 VDD.t240 VDD.t239 pfet_03v3 ad=1.1p pd=5.88u as=0 ps=0 w=2.5u l=4u
X400 a_984_3630# B04_OTA_bias_ratio_025_0.Vbias2 a_5044_4366# GND.t235 nfet_03v3 ad=0.22p pd=1.88u as=0.22p ps=1.88u w=0.5u l=4u
X401 a_696_n2762# VDD05.t46 a_984_n2762# VDD.t41 pfet_03v3 ad=0.13p pd=1.02u as=0.13p ps=1.02u w=0.5u l=1u
X402 GND.t501 GND.t502 cap_mim_2f0_m4m5_noshield c_width=10u c_length=10u
X403 a_32994_n2430# B04_OTA_4.Vbias2 a_37054_n1694# GND.t279 nfet_03v3 ad=0.22p pd=1.88u as=0.22p ps=1.88u w=0.5u l=4u
X404 B04_OTA_bias_ratio_025_1.Vbias0 B04_OTA_bias_ratio_025_1.Vbias3 a_16770_n10160# VDD.t147 pfet_03v3 ad=2.2p pd=10.88u as=2.2p ps=10.88u w=5u l=4u
X405 GND.t497 GND.t498 cap_mim_2f0_m4m5_noshield c_width=10u c_length=10u
X406 VDD05.t9 B04_OTA_8.Vin- cap_mim_2f0_m4m5_noshield c_width=10u c_length=10u
X407 B04_OTA_3.Vin- a_31752_6250# cap_mim_2f0_m4m5_noshield c_width=10u c_length=10u
X408 B04_OTA_7.Vin+ a_20752_6250# cap_mim_2f0_m4m5_noshield c_width=10u c_length=10u
X409 a_16676_n2762# B04_OTA_bias_ratio_025_1.Vbias3 a_15714_n1694# VDD.t145 pfet_03v3 ad=1.1p pd=5.88u as=1.1p ps=5.88u w=2.5u l=4u
X410 GND.t985 GND.t983 GND.t985 GND.t984 nfet_03v3 ad=0.22p pd=1.88u as=0 ps=0 w=0.5u l=4u
X411 GND.t553 GND.t554 cap_mim_2f0_m4m5_noshield c_width=10u c_length=10u
X412 B04_OTA_7.Vin+ GND.t97 cap_mim_2f0_m4m5_noshield c_width=10u c_length=10u
X413 B04_OTA_4.Vin- GND.t224 cap_mim_2f0_m4m5_noshield c_width=10u c_length=10u
X414 a_12552_n4544# B04_OTA_bias_ratio_025_1.Vbias2 a_12264_n4544# GND.t256 nfet_03v3 ad=0.44p pd=2.88u as=0.44p ps=2.88u w=1u l=1u
X415 a_45272_n4132# a_44374_n2762# GND.t417 GND.t416 nfet_03v3 ad=0.22p pd=1.88u as=0.22p ps=1.88u w=0.5u l=4u
X416 a_33892_n4132# B04_OTA_4.Vbias2 a_32994_n2762# GND.t275 nfet_03v3 ad=0.44p pd=2.88u as=0.44p ps=2.88u w=1u l=1u
X417 B04_OTA_6.Vin- GND.t335 cap_mim_2f0_m4m5_noshield c_width=10u c_length=10u
X418 a_33892_1516# B04_OTA_4.Vbias2 a_33604_1516# GND.t269 nfet_03v3 ad=0.44p pd=2.88u as=0.44p ps=2.88u w=1u l=1u
X419 a_34354_n2430# B04_OTA_4.Vin- a_32706_n2762# VDD.t84 pfet_03v3 ad=0.13p pd=1.02u as=0.22p ps=1.88u w=0.5u l=1u
X420 a_45734_n2430# B04_OTA_8.Vin- a_44086_n2762# VDD.t116 pfet_03v3 ad=0.13p pd=1.02u as=0.13p ps=1.02u w=0.5u l=1u
X421 B04_OTA_7.Vin+ a_21752_6250# cap_mim_2f0_m4m5_noshield c_width=10u c_length=10u
X422 B04_OTA_7.Vin+ a_21752_6250# cap_mim_2f0_m4m5_noshield c_width=10u c_length=10u
X423 B04_OTA_6.Vin- GND.t370 cap_mim_2f0_m4m5_noshield c_width=10u c_length=10u
X424 B04_OTA_6.Vin- a_19752_n13750# cap_mim_2f0_m4m5_noshield c_width=10u c_length=10u
X425 B04_OTA_4.Vin- GND.t222 cap_mim_2f0_m4m5_noshield c_width=10u c_length=10u
X426 B04_OTA_3.Vin- a_32752_6250# cap_mim_2f0_m4m5_noshield c_width=10u c_length=10u
X427 GND.t589 GND.t590 cap_mim_2f0_m4m5_noshield c_width=10u c_length=10u
X428 GND.t705 GND.t706 cap_mim_2f0_m4m5_noshield c_width=10u c_length=10u
X429 a_1882_1516# a_1594_1516# GND.t311 GND.t308 nfet_03v3 ad=0.22p pd=1.88u as=0.22p ps=1.88u w=0.5u l=4u
X430 a_23684_3630# B04_OTA_bias_ratio_04_0.Vbias2 B04_OTA_3.Vin- GND.t61 nfet_03v3 ad=0.22p pd=1.88u as=0.22p ps=1.88u w=0.5u l=4u
X431 GND.t815 GND.t816 cap_mim_2f0_m4m5_noshield c_width=10u c_length=10u
X432 B04_OTA_4.Vin- a_32752_n13750# cap_mim_2f0_m4m5_noshield c_width=10u c_length=10u
X433 VDD.t212 VDD.t211 VDD.t212 VDD.t196 pfet_03v3 ad=1.1p pd=5.88u as=0 ps=0 w=2.5u l=4u
X434 a_2344_3630# B04_OTA_bias_ratio_025_0.Vbias1 GND.t296 GND.t295 nfet_03v3 ad=0.22p pd=1.88u as=0.22p ps=1.88u w=0.5u l=4u
X435 a_6006_n2762# a_5044_n1694# VDD.t153 VDD.t152 pfet_03v3 ad=1.1p pd=5.88u as=1.1p ps=5.88u w=2.5u l=4u
X436 B04_OTA_3.Vin- a_30752_6250# cap_mim_2f0_m4m5_noshield c_width=10u c_length=10u
X437 B04_OTA_3.Vin- GND.t7 cap_mim_2f0_m4m5_noshield c_width=10u c_length=10u
X438 GND.t717 GND.t718 cap_mim_2f0_m4m5_noshield c_width=10u c_length=10u
X439 B04_OTA_7.Vin+ GND.t108 cap_mim_2f0_m4m5_noshield c_width=10u c_length=10u
X440 B04_OTA_4.Vin- GND.t195 cap_mim_2f0_m4m5_noshield c_width=10u c_length=10u
X441 GND.t739 GND.t740 cap_mim_2f0_m4m5_noshield c_width=10u c_length=10u
X442 VDD05.t11 B04_OTA_8.Vin- cap_mim_2f0_m4m5_noshield c_width=10u c_length=10u
X443 a_22324_3298# VDD05.t63 a_22036_3298# VDD.t32 pfet_03v3 ad=0.13p pd=1.02u as=0.22p ps=1.88u w=0.5u l=1u
X444 GND.t1068 GND.t1067 GND.t1068 GND.t1056 nfet_03v3 ad=0.44p pd=2.88u as=0 ps=0 w=1u l=1u
X445 a_38016_n2762# B04_OTA_4.Vbias3 a_37054_n1694# VDD.t12 pfet_03v3 ad=1.1p pd=5.88u as=1.1p ps=5.88u w=2.5u l=4u
X446 B04_OTA_6.Vin- GND.t339 cap_mim_2f0_m4m5_noshield c_width=10u c_length=10u
X447 VDD.t217 VDD.t215 VDD.t217 VDD.t216 pfet_03v3 ad=1.1p pd=5.88u as=0 ps=0 w=2.5u l=4u
X448 a_15714_4366# B04_OTA_bias_ratio_025_1.Vbias3 a_16676_3298# VDD.t126 pfet_03v3 ad=1.1p pd=5.88u as=1.1p ps=5.88u w=2.5u l=4u
X449 VDD.t377 a_26384_n1694# a_27346_n2762# VDD.t136 pfet_03v3 ad=1.1p pd=5.88u as=1.1p ps=5.88u w=2.5u l=4u
X450 B04_OTA_6.Vin- a_21752_n13750# cap_mim_2f0_m4m5_noshield c_width=10u c_length=10u
X451 B04_OTA_6.Vin- a_20752_n13750# cap_mim_2f0_m4m5_noshield c_width=10u c_length=10u
X452 B04_OTA_7.Vin+ a_21752_6250# cap_mim_2f0_m4m5_noshield c_width=10u c_length=10u
X453 B04_OTA_4.Vin- a_30752_n13750# cap_mim_2f0_m4m5_noshield c_width=10u c_length=10u
X454 B04_OTA_4.Vin- a_32752_n13750# cap_mim_2f0_m4m5_noshield c_width=10u c_length=10u
X455 B04_OTA_7.Vin+ a_20752_6250# cap_mim_2f0_m4m5_noshield c_width=10u c_length=10u
X456 B04_OTA_4.Vin- GND.t193 cap_mim_2f0_m4m5_noshield c_width=10u c_length=10u
X457 VDD.t312 VDD.t311 VDD.t312 VDD.t296 pfet_03v3 ad=1.1p pd=5.88u as=0 ps=0 w=2.5u l=4u
X458 B04_OTA_bias_ratio_04_0.Vbias0 VDD.t392 B04_OTA_bias_ratio_04_0.Vbias3 GND.t413 nfet_03v3 ad=4.4p pd=20.88u as=4.4p ps=20.88u w=10u l=4u
X459 a_32706_3298# B04_OTA_3.Vin- a_32994_3298# VDD.t5 pfet_03v3 ad=0.13p pd=1.02u as=0.13p ps=1.02u w=0.5u l=1u
X460 GND.t671 GND.t672 cap_mim_2f0_m4m5_noshield c_width=10u c_length=10u
X461 GND.t924 GND.t923 GND.t924 GND.t919 nfet_03v3 ad=0.22p pd=1.88u as=0 ps=0 w=0.5u l=4u
X462 B04_OTA_6.Vin- B04_OTA_bias_ratio_025_0.Vbias2 a_2344_n2430# GND.t239 nfet_03v3 ad=0.22p pd=1.88u as=0.22p ps=1.88u w=0.5u l=4u
X463 B04_OTA_6.Vin- a_21752_n13750# cap_mim_2f0_m4m5_noshield c_width=10u c_length=10u
X464 a_12552_n4544# a_12264_n4544# GND.t249 GND.t247 nfet_03v3 ad=0.22p pd=1.88u as=0.22p ps=1.88u w=0.5u l=4u
X465 B04_OTA_7.Vin+ GND.t84 cap_mim_2f0_m4m5_noshield c_width=10u c_length=10u
X466 B04_OTA_3.Vin- a_32752_6250# cap_mim_2f0_m4m5_noshield c_width=10u c_length=10u
X467 B04_OTA_3.Vin- a_32752_6250# cap_mim_2f0_m4m5_noshield c_width=10u c_length=10u
X468 VDD.t55 a_37054_4366# a_38016_3298# VDD.t54 pfet_03v3 ad=1.1p pd=5.88u as=1.1p ps=5.88u w=2.5u l=4u
X469 GND.t170 a_22934_1516# a_23222_1516# GND.t169 nfet_03v3 ad=0.22p pd=1.88u as=0.22p ps=1.88u w=0.5u l=4u
X470 GND.t625 GND.t626 cap_mim_2f0_m4m5_noshield c_width=10u c_length=10u
X471 a_26384_n1694# B04_OTA_bias_ratio_04_0.Vbias2 a_22324_n2430# GND.t65 nfet_03v3 ad=0.22p pd=1.88u as=0.22p ps=1.88u w=0.5u l=4u
X472 B04_OTA_3.Vin- a_30752_6250# cap_mim_2f0_m4m5_noshield c_width=10u c_length=10u
X473 a_1594_n4544# B04_OTA_7.Vin+ a_696_n2762# VDD.t44 pfet_03v3 ad=0.13p pd=1.02u as=0.22p ps=1.88u w=0.5u l=1u
X474 VDD.t300 VDD.t298 VDD.t300 VDD.t299 pfet_03v3 ad=1.1p pd=5.88u as=0 ps=0 w=2.5u l=4u
X475 GND.t958 GND.t956 GND.t958 GND.t957 nfet_03v3 ad=0.22p pd=1.88u as=0 ps=0 w=0.5u l=4u
X476 a_23222_n4132# B04_OTA_bias_ratio_04_0.Vbias2 a_22324_n2762# GND.t62 nfet_03v3 ad=0.44p pd=2.88u as=0.44p ps=2.88u w=1u l=1u
X477 B04_OTA_3.Vin- GND.t34 cap_mim_2f0_m4m5_noshield c_width=10u c_length=10u
X478 Vout.t1 B04_OTA_8.Vin- B04_OTA_8.Vin- Vout.t0 pfet_03v3 ad=0.22p pd=1.88u as=0.22p ps=1.88u w=0.5u l=4u
X479 B04_OTA_7.Vin+ GND.t102 cap_mim_2f0_m4m5_noshield c_width=10u c_length=10u
X480 B04_OTA_7.Vin+ GND.t106 cap_mim_2f0_m4m5_noshield c_width=10u c_length=10u
X481 B04_OTA_6.Vin- a_21752_n13750# cap_mim_2f0_m4m5_noshield c_width=10u c_length=10u
X482 B04_OTA_6.Vin- a_20752_n13750# cap_mim_2f0_m4m5_noshield c_width=10u c_length=10u
X483 a_22036_n2762# VDD05.t32 a_23684_n2430# VDD.t75 pfet_03v3 ad=0.22p pd=1.88u as=0.13p ps=1.02u w=0.5u l=1u
X484 a_1882_n4544# B04_OTA_bias_ratio_025_0.Vbias2 a_1594_n4544# GND.t237 nfet_03v3 ad=0.44p pd=2.88u as=0.44p ps=2.88u w=1u l=1u
X485 VDD.t257 VDD.t255 VDD.t257 VDD.t256 pfet_03v3 ad=1.1p pd=5.88u as=0 ps=0 w=2.5u l=4u
X486 a_32706_3298# B04_OTA_4.Vbias0 VDD.t105 VDD.t104 pfet_03v3 ad=0.65p pd=3.02u as=1.1p ps=5.88u w=2.5u l=4u
X487 VDD.t270 VDD.t269 VDD.t270 VDD.t265 pfet_03v3 ad=0.22p pd=1.88u as=0 ps=0 w=0.5u l=1u
X488 a_37054_4366# B04_OTA_4.Vbias3 a_38016_3298# VDD.t52 pfet_03v3 ad=1.1p pd=5.88u as=1.1p ps=5.88u w=2.5u l=4u
X489 a_11366_n2762# B04_OTA_6.Vin- a_11654_n2762# VDD.t65 pfet_03v3 ad=0.13p pd=1.02u as=0.13p ps=1.02u w=0.5u l=1u
X490 B04_OTA_6.Vin- a_20752_n13750# cap_mim_2f0_m4m5_noshield c_width=10u c_length=10u
X491 a_984_3630# Vin.t5 a_696_3298# VDD.t58 pfet_03v3 ad=0.13p pd=1.02u as=0.13p ps=1.02u w=0.5u l=1u
X492 B04_OTA_7.Vin+ a_21752_6250# cap_mim_2f0_m4m5_noshield c_width=10u c_length=10u
X493 GND.t481 GND.t482 cap_mim_2f0_m4m5_noshield c_width=10u c_length=10u
X494 B04_OTA_7.Vin+ a_20752_6250# cap_mim_2f0_m4m5_noshield c_width=10u c_length=10u
X495 a_32706_3298# B04_OTA_3.Vin- a_34354_3630# VDD.t1 pfet_03v3 ad=0.13p pd=1.02u as=0.13p ps=1.02u w=0.5u l=1u
X496 GND.t293 B04_OTA_bias_ratio_025_0.Vbias1 a_2344_3630# GND.t292 nfet_03v3 ad=0.22p pd=1.88u as=0.22p ps=1.88u w=0.5u l=4u
X497 VDD.t328 VDD.t327 VDD.t328 VDD.t322 pfet_03v3 ad=0.22p pd=1.88u as=0 ps=0 w=0.5u l=1u
X498 a_13014_n2430# a_12264_n4544# GND.t248 GND.t247 nfet_03v3 ad=0.22p pd=1.88u as=0.22p ps=1.88u w=0.5u l=4u
X499 GND.t315 a_11654_3298# a_12552_1928# GND.t314 nfet_03v3 ad=0.22p pd=1.88u as=0.22p ps=1.88u w=0.5u l=4u
X500 B04_OTA_6.Vin- a_21752_n13750# cap_mim_2f0_m4m5_noshield c_width=10u c_length=10u
X501 GND.t759 GND.t760 cap_mim_2f0_m4m5_noshield c_width=10u c_length=10u
X502 B04_OTA_4.Vin- GND.t227 cap_mim_2f0_m4m5_noshield c_width=10u c_length=10u
X503 B04_OTA_3.Vin- a_32752_6250# cap_mim_2f0_m4m5_noshield c_width=10u c_length=10u
X504 a_12552_1516# B04_OTA_bias_ratio_025_1.Vbias2 a_12264_1516# GND.t250 nfet_03v3 ad=0.44p pd=2.88u as=0.44p ps=2.88u w=1u l=1u
X505 B04_OTA_4.Vbias2 VbiasP.t1 VDD.t163 VDD.t162 pfet_03v3 ad=0.88p pd=4.88u as=0.88p ps=4.88u w=2u l=4u
X506 B04_OTA_6.Vin- B04_OTA_bias_ratio_025_0.Vbias3 a_4956_n2762# VDD.t148 pfet_03v3 ad=1.1p pd=5.88u as=1.1p ps=5.88u w=2.5u l=4u
X507 GND.t992 GND.t991 GND.t992 GND.t981 nfet_03v3 ad=0.44p pd=2.88u as=0 ps=0 w=1u l=1u
X508 B04_OTA_4.Vin- a_30752_n13750# cap_mim_2f0_m4m5_noshield c_width=10u c_length=10u
X509 GND.t1034 GND.t1032 GND.t1034 GND.t1033 nfet_03v3 ad=0.44p pd=2.88u as=0 ps=0 w=1u l=1u
X510 GND.t533 GND.t534 cap_mim_2f0_m4m5_noshield c_width=10u c_length=10u
X511 B04_OTA_3.Vin- GND.t32 cap_mim_2f0_m4m5_noshield c_width=10u c_length=10u
X512 B04_OTA_4.Vin- a_31752_n13750# cap_mim_2f0_m4m5_noshield c_width=10u c_length=10u
X513 GND.t976 GND.t975 GND.t976 GND.t970 nfet_03v3 ad=0.22p pd=1.88u as=0 ps=0 w=0.5u l=4u
X514 B04_OTA_3.Vin- GND.t30 cap_mim_2f0_m4m5_noshield c_width=10u c_length=10u
X515 a_4956_3298# a_5044_4366# VDD.t19 VDD.t18 pfet_03v3 ad=1.1p pd=5.88u as=1.1p ps=5.88u w=2.5u l=4u
X516 a_26384_n1694# B04_OTA_bias_ratio_04_0.Vbias3 a_27346_n2762# VDD.t135 pfet_03v3 ad=1.1p pd=5.88u as=1.1p ps=5.88u w=2.5u l=4u
X517 B04_OTA_4.Vin- a_32752_n13750# cap_mim_2f0_m4m5_noshield c_width=10u c_length=10u
X518 VDD.t292 VDD.t291 VDD.t292 VDD.t276 pfet_03v3 ad=1.1p pd=5.88u as=0 ps=0 w=2.5u l=4u
X519 a_16676_n2762# a_15714_n1694# VDD.t183 VDD.t144 pfet_03v3 ad=1.1p pd=5.88u as=1.1p ps=5.88u w=2.5u l=4u
X520 a_32706_n2762# B04_OTA_4.Vin- a_32994_n2762# VDD.t81 pfet_03v3 ad=0.13p pd=1.02u as=0.13p ps=1.02u w=0.5u l=1u
X521 a_44086_n2762# B04_OTA_8.Vin- a_44374_n2762# VDD.t121 pfet_03v3 ad=0.22p pd=1.88u as=0.13p ps=1.02u w=0.5u l=1u
X522 B04_OTA_7.Vin+ a_21752_6250# cap_mim_2f0_m4m5_noshield c_width=10u c_length=10u
X523 GND.t833 GND.t834 cap_mim_2f0_m4m5_noshield c_width=10u c_length=10u
X524 GND.t519 GND.t520 cap_mim_2f0_m4m5_noshield c_width=10u c_length=10u
X525 B04_OTA_6.Vin- a_21752_n13750# cap_mim_2f0_m4m5_noshield c_width=10u c_length=10u
X526 a_22324_3630# B04_OTA_bias_ratio_04_0.Vbias1 GND.t447 GND.t446 nfet_03v3 ad=0.22p pd=1.88u as=0.22p ps=1.88u w=0.5u l=4u
X527 B04_OTA_3.Vin- a_32752_6250# cap_mim_2f0_m4m5_noshield c_width=10u c_length=10u
X528 a_11654_3630# B04_OTA_bias_ratio_025_1.Vbias2 a_15714_4366# GND.t254 nfet_03v3 ad=0.22p pd=1.88u as=0.22p ps=1.88u w=0.5u l=4u
X529 B04_OTA_4.Vin- GND.t198 cap_mim_2f0_m4m5_noshield c_width=10u c_length=10u
X530 a_36966_3298# a_37054_4366# VDD.t51 VDD.t50 pfet_03v3 ad=1.1p pd=5.88u as=1.1p ps=5.88u w=2.5u l=4u
X531 a_23222_1928# a_22324_3298# GND.t146 GND.t145 nfet_03v3 ad=0.22p pd=1.88u as=0.22p ps=1.88u w=0.5u l=4u
X532 a_11654_n2430# VDD05.t41 a_11366_n2762# VDD.t66 pfet_03v3 ad=0.13p pd=1.02u as=0.13p ps=1.02u w=0.5u l=1u
X533 VDD.t17 a_5044_4366# a_4956_3298# VDD.t16 pfet_03v3 ad=1.1p pd=5.88u as=1.1p ps=5.88u w=2.5u l=4u
X534 a_6006_3298# B04_OTA_bias_ratio_025_0.Vbias3 a_5044_4366# VDD.t22 pfet_03v3 ad=1.1p pd=5.88u as=1.1p ps=5.88u w=2.5u l=4u
X535 a_44374_n2762# B04_OTA_bias_ratio_5_0.Vbias2 a_45272_n4132# GND.t387 nfet_03v3 ad=0.44p pd=2.88u as=0.44p ps=2.88u w=1u l=1u
X536 B04_OTA_7.Vin+ a_21752_6250# cap_mim_2f0_m4m5_noshield c_width=10u c_length=10u
X537 GND.t829 GND.t830 cap_mim_2f0_m4m5_noshield c_width=10u c_length=10u
X538 B04_OTA_4.Vin- a_32752_n13750# cap_mim_2f0_m4m5_noshield c_width=10u c_length=10u
X539 B04_OTA_3.Vin- GND.t37 cap_mim_2f0_m4m5_noshield c_width=10u c_length=10u
X540 B04_OTA_6.Vin- GND.t361 cap_mim_2f0_m4m5_noshield c_width=10u c_length=10u
X541 GND.t860 GND.t859 GND.t860 GND.t848 nfet_03v3 ad=0.44p pd=2.88u as=0 ps=0 w=1u l=1u
X542 GND.t1084 a_984_3298# a_1882_1928# GND.t1083 nfet_03v3 ad=0.22p pd=1.88u as=0.22p ps=1.88u w=0.5u l=4u
X543 VDD.t283 VDD.t281 VDD.t283 VDD.t282 pfet_03v3 ad=0.22p pd=1.88u as=0 ps=0 w=0.5u l=1u
X544 GND.t971 GND.t969 GND.t971 GND.t970 nfet_03v3 ad=0.22p pd=1.88u as=0 ps=0 w=0.5u l=4u
X545 B04_OTA_4.Vin- GND.t196 cap_mim_2f0_m4m5_noshield c_width=10u c_length=10u
X546 GND.t901 GND.t899 GND.t901 GND.t900 nfet_03v3 ad=0.44p pd=2.88u as=0 ps=0 w=1u l=1u
X547 a_32706_n2762# VDD05.t24 a_32994_n2430# VDD.t83 pfet_03v3 ad=0.22p pd=1.88u as=0.13p ps=1.02u w=0.5u l=1u
X548 B04_OTA_6.Vin- B04_OTA_bias_ratio_025_1.Vbias2 a_13014_n2430# GND.t258 nfet_03v3 ad=0.22p pd=1.88u as=0.22p ps=1.88u w=0.5u l=4u
X549 GND.t1014 GND.t1012 GND.t1014 GND.t1013 nfet_03v3 ad=0.22p pd=1.88u as=0 ps=0 w=0.5u l=4u
X550 B04_OTA_3.Vin- GND.t15 cap_mim_2f0_m4m5_noshield c_width=10u c_length=10u
X551 GND.t138 Cap2.t2 a_32752_6250# GND.t137 nfet_03v3 ad=0.22p pd=1.88u as=0.22p ps=1.88u w=0.5u l=1u
X552 VDD.t308 VDD.t307 VDD.t308 VDD.t302 pfet_03v3 ad=0.22p pd=1.88u as=0 ps=0 w=0.5u l=1u
X553 B04_OTA_7.Vin+ GND.t89 cap_mim_2f0_m4m5_noshield c_width=10u c_length=10u
X554 GND.t689 GND.t690 cap_mim_2f0_m4m5_noshield c_width=10u c_length=10u
X555 B04_OTA_6.Vin- a_21752_n13750# cap_mim_2f0_m4m5_noshield c_width=10u c_length=10u
X556 B04_OTA_4.Vin- GND.t230 cap_mim_2f0_m4m5_noshield c_width=10u c_length=10u
X557 GND.t711 GND.t712 cap_mim_2f0_m4m5_noshield c_width=10u c_length=10u
X558 a_22036_n2762# B04_OTA_6.Vin- a_22324_n2430# VDD.t77 pfet_03v3 ad=0.13p pd=1.02u as=0.13p ps=1.02u w=0.5u l=1u
X559 B04_OTA_bias_ratio_5_0.Vbias1 B04_OTA_bias_ratio_5_0.Vbias2 a_45120_n9520# GND.t392 nfet_03v3 ad=0.44p pd=2.88u as=0.44p ps=2.88u w=1u l=4u
X560 B04_OTA_6.Vin- GND.t367 cap_mim_2f0_m4m5_noshield c_width=10u c_length=10u
X561 a_12264_n4544# VDD05.t39 a_11366_n2762# VDD.t68 pfet_03v3 ad=0.13p pd=1.02u as=0.22p ps=1.88u w=0.5u l=1u
X562 B04_OTA_7.Vin+ a_21752_6250# cap_mim_2f0_m4m5_noshield c_width=10u c_length=10u
X563 B04_OTA_7.Vin+ a_21752_6250# cap_mim_2f0_m4m5_noshield c_width=10u c_length=10u
X564 B04_OTA_7.Vin+ a_21752_6250# cap_mim_2f0_m4m5_noshield c_width=10u c_length=10u
X565 a_22324_3298# B04_OTA_bias_ratio_04_0.Vbias2 a_23222_1928# GND.t57 nfet_03v3 ad=0.44p pd=2.88u as=0.44p ps=2.88u w=1u l=1u
X566 VDD.t306 VDD.t304 VDD.t306 VDD.t305 pfet_03v3 ad=0.22p pd=1.88u as=0 ps=0 w=0.5u l=1u
X567 VDD.t343 VDD.t341 VDD.t343 VDD.t342 pfet_03v3 ad=0.22p pd=1.88u as=0 ps=0 w=0.5u l=1u
X568 B04_OTA_3.Vin- a_32752_6250# cap_mim_2f0_m4m5_noshield c_width=10u c_length=10u
X569 GND.t761 GND.t762 cap_mim_2f0_m4m5_noshield c_width=10u c_length=10u
X570 a_27346_3298# a_26384_4366# VDD.t140 VDD.t131 pfet_03v3 ad=1.1p pd=5.88u as=1.1p ps=5.88u w=2.5u l=4u
X571 a_26296_3298# B04_OTA_bias_ratio_04_0.Vbias3 B04_OTA_3.Vin- VDD.t133 pfet_03v3 ad=1.1p pd=5.88u as=1.1p ps=5.88u w=2.5u l=4u
X572 GND.t423 a_33604_1516# a_33892_1516# GND.t422 nfet_03v3 ad=0.22p pd=1.88u as=0.22p ps=1.88u w=0.5u l=4u
X573 GND.t581 GND.t582 cap_mim_2f0_m4m5_noshield c_width=10u c_length=10u
X574 B04_OTA_6.Vin- a_21752_n13750# cap_mim_2f0_m4m5_noshield c_width=10u c_length=10u
X575 GND.t685 GND.t686 cap_mim_2f0_m4m5_noshield c_width=10u c_length=10u
X576 GND.t1078 GND.t1077 GND.t1078 GND.t1072 nfet_03v3 ad=0.22p pd=1.88u as=0 ps=0 w=0.5u l=4u
X577 VDD.t155 a_5044_n1694# a_6006_n2762# VDD.t154 pfet_03v3 ad=1.1p pd=5.88u as=1.1p ps=5.88u w=2.5u l=4u
X578 GND.t965 GND.t964 GND.t965 GND.t954 nfet_03v3 ad=0.44p pd=2.88u as=0 ps=0 w=1u l=1u
X579 B04_OTA_7.Vin+ a_21752_6250# cap_mim_2f0_m4m5_noshield c_width=10u c_length=10u
X580 a_11366_3298# B04_OTA_7.Vin+ a_13014_3630# VDD.t25 pfet_03v3 ad=0.13p pd=1.02u as=0.13p ps=1.02u w=0.5u l=1u
X581 GND.t795 GND.t796 cap_mim_2f0_m4m5_noshield c_width=10u c_length=10u
X582 VDD05.t18 B04_OTA_8.Vin- cap_mim_2f0_m4m5_noshield c_width=10u c_length=10u
X583 B04_OTA_bias_ratio_04_0.Vbias1 GND.t1089 B04_OTA_bias_ratio_04_0.Vbias2 VDD.t99 pfet_03v3 ad=2.2p pd=10.88u as=2.2p ps=10.88u w=5u l=4u
X584 B04_OTA_6.Vin- B04_OTA_4.Vbias2 a_34354_n2430# GND.t277 nfet_03v3 ad=0.22p pd=1.88u as=0.22p ps=1.88u w=0.5u l=4u
X585 B04_OTA_3.Vin- GND.t13 cap_mim_2f0_m4m5_noshield c_width=10u c_length=10u
X586 GND.t567 GND.t568 cap_mim_2f0_m4m5_noshield c_width=10u c_length=10u
X587 B04_OTA_6.Vin- a_21752_n13750# cap_mim_2f0_m4m5_noshield c_width=10u c_length=10u
X588 a_26296_n2762# a_26384_n1694# VDD.t378 VDD.t137 pfet_03v3 ad=1.1p pd=5.88u as=1.1p ps=5.88u w=2.5u l=4u
X589 B04_OTA_7.Vin+ GND.t91 cap_mim_2f0_m4m5_noshield c_width=10u c_length=10u
X590 B04_OTA_6.Vin- B04_OTA_bias_ratio_025_1.Vbias3 a_15626_n2762# VDD.t143 pfet_03v3 ad=1.1p pd=5.88u as=1.1p ps=5.88u w=2.5u l=4u
X591 VDD.t334 VDD.t333 VDD.t334 VDD.t319 pfet_03v3 ad=1.1p pd=5.88u as=0 ps=0 w=2.5u l=4u
X592 GND.t521 GND.t522 cap_mim_2f0_m4m5_noshield c_width=10u c_length=10u
X593 a_33604_n4544# VDD05.t23 a_32706_n2762# VDD.t84 pfet_03v3 ad=0.13p pd=1.02u as=0.22p ps=1.88u w=0.5u l=1u
X594 a_44984_n4544# B04_OTA_6.Vin- a_44086_n2762# VDD.t116 pfet_03v3 ad=0.13p pd=1.02u as=0.13p ps=1.02u w=0.5u l=1u
X595 GND.t1073 GND.t1071 GND.t1073 GND.t1072 nfet_03v3 ad=0.22p pd=1.88u as=0 ps=0 w=0.5u l=4u
X596 a_45272_n4544# a_44984_n4544# GND.t323 GND.t320 nfet_03v3 ad=0.22p pd=1.88u as=0.22p ps=1.88u w=0.5u l=4u
X597 GND.t635 GND.t636 cap_mim_2f0_m4m5_noshield c_width=10u c_length=10u
X598 a_984_n2430# B04_OTA_7.Vin+ a_696_n2762# VDD.t42 pfet_03v3 ad=0.13p pd=1.02u as=0.13p ps=1.02u w=0.5u l=1u
X599 VDD05.t5 B04_OTA_8.Vin- cap_mim_2f0_m4m5_noshield c_width=10u c_length=10u
X600 GND.t1002 GND.t1001 GND.t1002 GND.t997 nfet_03v3 ad=0.22p pd=1.88u as=0 ps=0 w=0.5u l=4u
X601 GND.t587 GND.t588 cap_mim_2f0_m4m5_noshield c_width=10u c_length=10u
X602 B04_OTA_4.Vin- a_31752_n13750# cap_mim_2f0_m4m5_noshield c_width=10u c_length=10u
X603 B04_OTA_6.Vin- a_21752_n13750# cap_mim_2f0_m4m5_noshield c_width=10u c_length=10u
X604 a_696_n2762# VDD05.t48 a_2344_n2430# VDD.t47 pfet_03v3 ad=0.22p pd=1.88u as=0.13p ps=1.02u w=0.5u l=1u
X605 a_33892_n4544# B04_OTA_4.Vbias2 a_33604_n4544# GND.t275 nfet_03v3 ad=0.44p pd=2.88u as=0.44p ps=2.88u w=1u l=1u
X606 B04_OTA_7.Vin+ GND.t87 cap_mim_2f0_m4m5_noshield c_width=10u c_length=10u
X607 a_33892_1928# B04_OTA_4.Vbias2 a_32994_3298# GND.t269 nfet_03v3 ad=0.44p pd=2.88u as=0.44p ps=2.88u w=1u l=1u
X608 B04_OTA_3.Vin- GND.t18 cap_mim_2f0_m4m5_noshield c_width=10u c_length=10u
X609 B04_OTA_4.Vin- a_32752_n13750# cap_mim_2f0_m4m5_noshield c_width=10u c_length=10u
X610 B04_OTA_6.Vin- a_20752_n13750# cap_mim_2f0_m4m5_noshield c_width=10u c_length=10u
X611 GND.t609 GND.t610 cap_mim_2f0_m4m5_noshield c_width=10u c_length=10u
X612 GND.t839 GND.t840 cap_mim_2f0_m4m5_noshield c_width=10u c_length=10u
X613 B04_OTA_6.Vin- a_20752_n13750# cap_mim_2f0_m4m5_noshield c_width=10u c_length=10u
X614 a_32706_3298# B04_OTA_3.Vin- a_34354_3630# VDD.t3 pfet_03v3 ad=0.22p pd=1.88u as=0.13p ps=1.02u w=0.5u l=1u
X615 B04_OTA_4.Vin- a_31752_n13750# cap_mim_2f0_m4m5_noshield c_width=10u c_length=10u
X616 GND.t491 GND.t492 cap_mim_2f0_m4m5_noshield c_width=10u c_length=10u
X617 B04_OTA_7.Vin+ GND.t100 cap_mim_2f0_m4m5_noshield c_width=10u c_length=10u
X618 GND.t749 GND.t750 cap_mim_2f0_m4m5_noshield c_width=10u c_length=10u
X619 GND.t713 GND.t714 cap_mim_2f0_m4m5_noshield c_width=10u c_length=10u
X620 B04_OTA_6.Vin- a_19752_n13750# cap_mim_2f0_m4m5_noshield c_width=10u c_length=10u
X621 GND.t940 GND.t939 GND.t940 GND.t929 nfet_03v3 ad=0.44p pd=2.88u as=0 ps=0 w=1u l=1u
X622 a_45734_n2430# a_44984_n4544# GND.t321 GND.t320 nfet_03v3 ad=0.22p pd=1.88u as=0.22p ps=1.88u w=0.5u l=4u
X623 GND.t835 GND.t836 cap_mim_2f0_m4m5_noshield c_width=10u c_length=10u
X624 GND.t771 GND.t772 cap_mim_2f0_m4m5_noshield c_width=10u c_length=10u
X625 B04_OTA_6.Vin- B04_OTA_4.Vbias3 a_36966_n2762# VDD.t10 pfet_03v3 ad=1.1p pd=5.88u as=1.1p ps=5.88u w=2.5u l=4u
X626 a_22036_3298# B04_OTA_7.Vin+ a_22324_3630# VDD.t33 pfet_03v3 ad=0.13p pd=1.02u as=0.13p ps=1.02u w=0.5u l=1u
X627 VDD.t375 a_26384_n1694# a_26296_n2762# VDD.t134 pfet_03v3 ad=1.1p pd=5.88u as=1.1p ps=5.88u w=2.5u l=4u
X628 GND.t998 GND.t996 GND.t998 GND.t997 nfet_03v3 ad=0.22p pd=1.88u as=0 ps=0 w=0.5u l=4u
X629 B04_OTA_6.Vin- a_21752_n13750# cap_mim_2f0_m4m5_noshield c_width=10u c_length=10u
X630 GND.t465 GND.t466 cap_mim_2f0_m4m5_noshield c_width=10u c_length=10u
X631 B04_OTA_4.Vin- GND.t205 cap_mim_2f0_m4m5_noshield c_width=10u c_length=10u
X632 B04_OTA_6.Vin- GND.t344 cap_mim_2f0_m4m5_noshield c_width=10u c_length=10u
X633 a_984_3298# VDD05.t77 a_696_3298# VDD.t58 pfet_03v3 ad=0.13p pd=1.02u as=0.13p ps=1.02u w=0.5u l=1u
X634 B04_OTA_4.Vin- GND.t199 cap_mim_2f0_m4m5_noshield c_width=10u c_length=10u
X635 VDD05.t7 B04_OTA_8.Vin- cap_mim_2f0_m4m5_noshield c_width=10u c_length=10u
X636 B04_OTA_7.Vin+ GND.t95 cap_mim_2f0_m4m5_noshield c_width=10u c_length=10u
X637 B04_OTA_6.Vin- a_20752_n13750# cap_mim_2f0_m4m5_noshield c_width=10u c_length=10u
X638 a_32706_3298# VDD05.t54 a_33604_1516# VDD.t1 pfet_03v3 ad=0.13p pd=1.02u as=0.13p ps=1.02u w=0.5u l=1u
X639 GND.t695 GND.t696 cap_mim_2f0_m4m5_noshield c_width=10u c_length=10u
X640 B04_OTA_6.Vin- GND.t331 cap_mim_2f0_m4m5_noshield c_width=10u c_length=10u
X641 B04_OTA_bias_ratio_025_1.Vbias2 VbiasP.t3 VDD.t161 VDD.t160 pfet_03v3 ad=0.55p pd=3.38u as=0.55p ps=3.38u w=1.25u l=4u
X642 B04_OTA_7.Vin+ a_21752_6250# cap_mim_2f0_m4m5_noshield c_width=10u c_length=10u
X643 B04_OTA_3.Vin- GND.t16 cap_mim_2f0_m4m5_noshield c_width=10u c_length=10u
X644 GND.t613 GND.t614 cap_mim_2f0_m4m5_noshield c_width=10u c_length=10u
X645 a_11654_n2430# B04_OTA_bias_ratio_025_1.Vbias1 GND.t160 GND.t159 nfet_03v3 ad=0.22p pd=1.88u as=0.22p ps=1.88u w=0.5u l=4u
X646 B04_OTA_3.Vin- GND.t45 cap_mim_2f0_m4m5_noshield c_width=10u c_length=10u
X647 B04_OTA_3.Vin- a_32752_6250# cap_mim_2f0_m4m5_noshield c_width=10u c_length=10u
X648 B04_OTA_4.Vin- GND.t203 cap_mim_2f0_m4m5_noshield c_width=10u c_length=10u
X649 a_15626_3298# a_15714_4366# VDD.t129 VDD.t128 pfet_03v3 ad=1.1p pd=5.88u as=1.1p ps=5.88u w=2.5u l=4u
X650 GND.t569 GND.t570 cap_mim_2f0_m4m5_noshield c_width=10u c_length=10u
X651 a_32994_3630# VDD05.t57 a_32706_3298# VDD.t6 pfet_03v3 ad=0.13p pd=1.02u as=0.13p ps=1.02u w=0.5u l=1u
X652 a_22036_n2762# B04_OTA_6.Vin- a_22934_n4544# VDD.t75 pfet_03v3 ad=0.22p pd=1.88u as=0.13p ps=1.02u w=0.5u l=1u
X653 GND.t1011 GND.t1009 GND.t1011 GND.t1010 nfet_03v3 ad=0.22p pd=1.88u as=0 ps=0 w=0.5u l=4u
X654 B04_OTA_3.Vin- a_31752_6250# cap_mim_2f0_m4m5_noshield c_width=10u c_length=10u
X655 GND.t691 GND.t692 cap_mim_2f0_m4m5_noshield c_width=10u c_length=10u
X656 VDD.t107 B04_OTA_4.Vbias0 a_32706_3298# VDD.t106 pfet_03v3 ad=1.1p pd=5.88u as=0.65p ps=3.02u w=2.5u l=4u
X657 VDD.t184 a_15714_n1694# a_16676_n2762# VDD.t145 pfet_03v3 ad=1.1p pd=5.88u as=1.1p ps=5.88u w=2.5u l=4u
X658 a_23222_n4544# B04_OTA_bias_ratio_04_0.Vbias2 a_22934_n4544# GND.t62 nfet_03v3 ad=0.44p pd=2.88u as=0.44p ps=2.88u w=1u l=1u
X659 B04_OTA_6.Vin- GND.t350 cap_mim_2f0_m4m5_noshield c_width=10u c_length=10u
X660 GND.t511 GND.t512 cap_mim_2f0_m4m5_noshield c_width=10u c_length=10u
X661 VDD.t125 a_15714_4366# a_15626_3298# VDD.t124 pfet_03v3 ad=1.1p pd=5.88u as=1.1p ps=5.88u w=2.5u l=4u
X662 a_16676_3298# B04_OTA_bias_ratio_025_1.Vbias3 a_15714_4366# VDD.t122 pfet_03v3 ad=1.1p pd=5.88u as=1.1p ps=5.88u w=2.5u l=4u
X663 a_13014_3630# a_12264_1516# GND.t179 GND.t177 nfet_03v3 ad=0.22p pd=1.88u as=0.22p ps=1.88u w=0.5u l=4u
X664 a_2910_n11110# B04_OTA_bias_ratio_025_0.Vbias1 GND.t305 GND.t304 nfet_03v3 ad=0.44p pd=2.88u as=0.44p ps=2.88u w=1u l=4u
X665 B04_OTA_4.Vin- a_32752_n13750# cap_mim_2f0_m4m5_noshield c_width=10u c_length=10u
X666 a_2344_3630# VDD05.t81 a_696_3298# VDD.t62 pfet_03v3 ad=0.13p pd=1.02u as=0.13p ps=1.02u w=0.5u l=1u
X667 GND.t469 GND.t470 cap_mim_2f0_m4m5_noshield c_width=10u c_length=10u
X668 GND.t605 GND.t606 cap_mim_2f0_m4m5_noshield c_width=10u c_length=10u
X669 GND.t128 Cap1.t2 a_31752_6250# GND.t127 nfet_03v3 ad=0.22p pd=1.88u as=0.22p ps=1.88u w=0.5u l=1u
X670 a_48434_n1694# B04_OTA_bias_ratio_5_0.Vbias2 a_44374_n2430# GND.t389 nfet_03v3 ad=0.22p pd=1.88u as=0.22p ps=1.88u w=0.5u l=4u
X671 a_27450_n10140# B04_OTA_bias_ratio_04_0.Vbias0 VDD.t98 VDD.t97 pfet_03v3 ad=2.2p pd=10.88u as=2.2p ps=10.88u w=5u l=4u
X672 B04_OTA_4.Vin- a_32752_n13750# cap_mim_2f0_m4m5_noshield c_width=10u c_length=10u
X673 a_45272_n4132# B04_OTA_bias_ratio_5_0.Vbias2 a_44374_n2762# GND.t386 nfet_03v3 ad=0.44p pd=2.88u as=0.44p ps=2.88u w=1u l=1u
X674 B04_OTA_7.Vin+ GND.t93 cap_mim_2f0_m4m5_noshield c_width=10u c_length=10u
X675 GND.t886 GND.t885 GND.t886 GND.t874 nfet_03v3 ad=0.44p pd=2.88u as=0 ps=0 w=1u l=1u
X676 a_13014_n2430# B04_OTA_bias_ratio_025_1.Vbias1 GND.t161 GND.t159 nfet_03v3 ad=0.22p pd=1.88u as=0.22p ps=1.88u w=0.5u l=4u
X677 GND.t531 GND.t532 cap_mim_2f0_m4m5_noshield c_width=10u c_length=10u
X678 a_32994_3630# a_32994_3298# GND.t5 GND.t0 nfet_03v3 ad=0.22p pd=1.88u as=0.22p ps=1.88u w=0.5u l=4u
X679 B04_OTA_3.Vin- GND.t43 cap_mim_2f0_m4m5_noshield c_width=10u c_length=10u
X680 B04_OTA_3.Vin- a_32752_6250# cap_mim_2f0_m4m5_noshield c_width=10u c_length=10u
X681 a_12552_1928# B04_OTA_bias_ratio_025_1.Vbias2 a_11654_3298# GND.t250 nfet_03v3 ad=0.44p pd=2.88u as=0.44p ps=2.88u w=1u l=1u
X682 B04_OTA_bias_ratio_025_0.Vbias2 VbiasP.t4 VDD.t159 VDD.t158 pfet_03v3 ad=0.55p pd=3.38u as=0.55p ps=3.38u w=1.25u l=4u
X683 a_11366_n2762# B04_OTA_6.Vin- a_13014_n2430# VDD.t71 pfet_03v3 ad=0.22p pd=1.88u as=0.13p ps=1.02u w=0.5u l=1u
X684 B04_OTA_6.Vin- a_21752_n13750# cap_mim_2f0_m4m5_noshield c_width=10u c_length=10u
X685 B04_OTA_4.Vin- a_31752_n13750# cap_mim_2f0_m4m5_noshield c_width=10u c_length=10u
X686 B04_OTA_3.Vin- a_31752_6250# cap_mim_2f0_m4m5_noshield c_width=10u c_length=10u
X687 VDD.t13 a_37054_n1694# a_38016_n2762# VDD.t12 pfet_03v3 ad=1.1p pd=5.88u as=1.1p ps=5.88u w=2.5u l=4u
X688 GND.t1044 GND.t1043 GND.t1044 GND.t1033 nfet_03v3 ad=0.44p pd=2.88u as=0 ps=0 w=1u l=1u
X689 GND.t621 GND.t622 cap_mim_2f0_m4m5_noshield c_width=10u c_length=10u
X690 GND.t378 a_1594_n4544# a_2344_n2430# GND.t374 nfet_03v3 ad=0.22p pd=1.88u as=0.22p ps=1.88u w=0.5u l=4u
X691 B04_OTA_3.Vin- a_31752_6250# cap_mim_2f0_m4m5_noshield c_width=10u c_length=10u
X692 GND.t136 Cap2.t3 a_21752_6250# GND.t135 nfet_03v3 ad=0.22p pd=1.88u as=0.22p ps=1.88u w=0.5u l=1u
X693 VDD.t332 VDD.t331 VDD.t332 VDD.t316 pfet_03v3 ad=1.1p pd=5.88u as=0 ps=0 w=2.5u l=4u
X694 B04_OTA_7.Vin+ a_21752_6250# cap_mim_2f0_m4m5_noshield c_width=10u c_length=10u
X695 GND.t845 GND.t846 cap_mim_2f0_m4m5_noshield c_width=10u c_length=10u
X696 VDD.t297 VDD.t295 VDD.t297 VDD.t296 pfet_03v3 ad=1.1p pd=5.88u as=0 ps=0 w=2.5u l=4u
X697 GND.t888 GND.t887 GND.t888 GND.t877 nfet_03v3 ad=0.44p pd=2.88u as=0 ps=0 w=1u l=1u
X698 B04_OTA_7.Vin+ GND.t104 cap_mim_2f0_m4m5_noshield c_width=10u c_length=10u
X699 GND.t651 GND.t652 cap_mim_2f0_m4m5_noshield c_width=10u c_length=10u
X700 a_11654_n2762# B04_OTA_6.Vin- a_11366_n2762# VDD.t66 pfet_03v3 ad=0.13p pd=1.02u as=0.13p ps=1.02u w=0.5u l=1u
X701 a_23222_n4544# a_22934_n4544# GND.t168 GND.t163 nfet_03v3 ad=0.22p pd=1.88u as=0.22p ps=1.88u w=0.5u l=4u
X702 B04_OTA_3.Vin- GND.t54 cap_mim_2f0_m4m5_noshield c_width=10u c_length=10u
X703 GND.t801 GND.t802 cap_mim_2f0_m4m5_noshield c_width=10u c_length=10u
X704 GND.t841 GND.t842 cap_mim_2f0_m4m5_noshield c_width=10u c_length=10u
X705 B04_OTA_6.Vin- a_20752_n13750# cap_mim_2f0_m4m5_noshield c_width=10u c_length=10u
X706 a_48434_n1694# B04_OTA_bias_ratio_5_0.Vbias3 a_49396_n2762# VDD.t187 pfet_03v3 ad=1.1p pd=5.88u as=1.1p ps=5.88u w=2.5u l=4u
X707 VDD.t288 VDD.t287 VDD.t288 VDD.t282 pfet_03v3 ad=0.22p pd=1.88u as=0 ps=0 w=0.5u l=1u
X708 GND.t1008 GND.t1006 GND.t1008 GND.t1007 nfet_03v3 ad=0.44p pd=2.88u as=0 ps=0 w=1u l=1u
X709 a_37054_n1694# B04_OTA_4.Vbias2 a_32994_n2430# GND.t278 nfet_03v3 ad=0.22p pd=1.88u as=0.22p ps=1.88u w=0.5u l=4u
X710 GND.t477 GND.t478 cap_mim_2f0_m4m5_noshield c_width=10u c_length=10u
X711 B04_OTA_6.Vin- a_21752_n13750# cap_mim_2f0_m4m5_noshield c_width=10u c_length=10u
X712 a_11366_3298# VDD05.t70 a_12264_1516# VDD.t25 pfet_03v3 ad=0.13p pd=1.02u as=0.13p ps=1.02u w=0.5u l=1u
X713 a_32706_n2762# B04_OTA_4.Vin- a_32994_n2762# VDD.t83 pfet_03v3 ad=0.22p pd=1.88u as=0.13p ps=1.02u w=0.5u l=1u
X714 B04_OTA_3.Vin- a_32752_6250# cap_mim_2f0_m4m5_noshield c_width=10u c_length=10u
X715 B04_OTA_4.Vin- GND.t208 cap_mim_2f0_m4m5_noshield c_width=10u c_length=10u
X716 a_2344_3630# a_1594_1516# GND.t309 GND.t308 nfet_03v3 ad=0.22p pd=1.88u as=0.22p ps=1.88u w=0.5u l=4u
X717 B04_OTA_6.Vin- a_21752_n13750# cap_mim_2f0_m4m5_noshield c_width=10u c_length=10u
X718 B04_OTA_6.Vin- a_19752_n13750# cap_mim_2f0_m4m5_noshield c_width=10u c_length=10u
X719 a_32706_n2762# B04_OTA_4.Vin- a_34354_n2430# VDD.t87 pfet_03v3 ad=0.22p pd=1.88u as=0.13p ps=1.02u w=0.5u l=1u
X720 GND.t375 a_1594_n4544# a_1882_n4544# GND.t374 nfet_03v3 ad=0.22p pd=1.88u as=0.22p ps=1.88u w=0.5u l=4u
X721 GND.t849 GND.t847 GND.t849 GND.t848 nfet_03v3 ad=0.44p pd=2.88u as=0 ps=0 w=1u l=1u
X722 B04_OTA_bias_ratio_025_0.Vbias0 VDD.t394 B04_OTA_bias_ratio_025_0.Vbias3 GND.t411 nfet_03v3 ad=4.4p pd=20.88u as=4.4p ps=20.88u w=10u l=4u
X723 GND.t507 GND.t508 cap_mim_2f0_m4m5_noshield c_width=10u c_length=10u
X724 B04_OTA_3.Vin- a_31752_6250# cap_mim_2f0_m4m5_noshield c_width=10u c_length=10u
X725 B04_OTA_3.Vin- GND.t27 cap_mim_2f0_m4m5_noshield c_width=10u c_length=10u
X726 GND.t701 GND.t702 cap_mim_2f0_m4m5_noshield c_width=10u c_length=10u
X727 GND.t948 GND.t947 GND.t948 GND.t942 nfet_03v3 ad=0.22p pd=1.88u as=0 ps=0 w=0.5u l=4u
X728 a_22036_n2762# VDD05.t30 a_22324_n2762# VDD.t77 pfet_03v3 ad=0.13p pd=1.02u as=0.13p ps=1.02u w=0.5u l=1u
X729 GND.t513 GND.t514 cap_mim_2f0_m4m5_noshield c_width=10u c_length=10u
X730 GND.t617 GND.t618 cap_mim_2f0_m4m5_noshield c_width=10u c_length=10u
X731 VDD.t200 VDD.t198 VDD.t200 VDD.t199 pfet_03v3 ad=1.1p pd=5.88u as=0 ps=0 w=2.5u l=4u
X732 B04_OTA_7.Vin+ a_20752_6250# cap_mim_2f0_m4m5_noshield c_width=10u c_length=10u
X733 B04_OTA_4.Vin- a_32752_n13750# cap_mim_2f0_m4m5_noshield c_width=10u c_length=10u
X734 VDD.t348 VDD.t347 VDD.t348 VDD.t342 pfet_03v3 ad=0.22p pd=1.88u as=0 ps=0 w=0.5u l=1u
X735 B04_OTA_4.Vin- GND.t206 cap_mim_2f0_m4m5_noshield c_width=10u c_length=10u
X736 GND.t743 GND.t744 cap_mim_2f0_m4m5_noshield c_width=10u c_length=10u
X737 GND.t723 GND.t724 cap_mim_2f0_m4m5_noshield c_width=10u c_length=10u
X738 VDD.t310 VDD.t309 VDD.t310 VDD.t305 pfet_03v3 ad=0.22p pd=1.88u as=0 ps=0 w=0.5u l=1u
X739 a_23684_n2430# a_22934_n4544# GND.t164 GND.t163 nfet_03v3 ad=0.22p pd=1.88u as=0.22p ps=1.88u w=0.5u l=4u
X740 GND.t579 GND.t580 cap_mim_2f0_m4m5_noshield c_width=10u c_length=10u
X741 GND.t813 GND.t814 cap_mim_2f0_m4m5_noshield c_width=10u c_length=10u
X742 B04_OTA_6.Vin- a_20752_n13750# cap_mim_2f0_m4m5_noshield c_width=10u c_length=10u
X743 GND.t647 GND.t648 cap_mim_2f0_m4m5_noshield c_width=10u c_length=10u
X744 B04_OTA_7.Vin+ GND.t79 cap_mim_2f0_m4m5_noshield c_width=10u c_length=10u
X745 B04_OTA_4.Vin- a_31752_n13750# cap_mim_2f0_m4m5_noshield c_width=10u c_length=10u
X746 GND.t697 GND.t698 cap_mim_2f0_m4m5_noshield c_width=10u c_length=10u
X747 GND.t657 GND.t658 cap_mim_2f0_m4m5_noshield c_width=10u c_length=10u
X748 a_984_3298# B04_OTA_bias_ratio_025_0.Vbias2 a_1882_1928# GND.t232 nfet_03v3 ad=0.44p pd=2.88u as=0.44p ps=2.88u w=1u l=1u
X749 a_22934_1516# B04_OTA_bias_ratio_04_0.Vbias2 a_23222_1516# GND.t57 nfet_03v3 ad=0.44p pd=2.88u as=0.44p ps=2.88u w=1u l=1u
X750 B04_OTA_4.Vin- a_32752_n13750# cap_mim_2f0_m4m5_noshield c_width=10u c_length=10u
X751 GND.t549 GND.t550 cap_mim_2f0_m4m5_noshield c_width=10u c_length=10u
X752 B04_OTA_3.Vin- GND.t52 cap_mim_2f0_m4m5_noshield c_width=10u c_length=10u
X753 a_44086_n2762# B04_OTA_6.Vin- a_44374_n2430# VDD.t119 pfet_03v3 ad=0.13p pd=1.02u as=0.13p ps=1.02u w=0.5u l=1u
X754 a_22036_3298# B04_OTA_7.Vin+ a_22324_3630# VDD.t35 pfet_03v3 ad=0.22p pd=1.88u as=0.13p ps=1.02u w=0.5u l=1u
X755 VDD.t149 a_5044_n1694# a_4956_n2762# VDD.t148 pfet_03v3 ad=1.1p pd=5.88u as=1.1p ps=5.88u w=2.5u l=4u
X756 GND.t473 GND.t474 cap_mim_2f0_m4m5_noshield c_width=10u c_length=10u
X757 B04_OTA_3.Vin- GND.t50 cap_mim_2f0_m4m5_noshield c_width=10u c_length=10u
X758 B04_OTA_6.Vin- GND.t372 cap_mim_2f0_m4m5_noshield c_width=10u c_length=10u
X759 VDD.t226 VDD.t224 VDD.t226 VDD.t225 pfet_03v3 ad=0.22p pd=1.88u as=0 ps=0 w=0.5u l=1u
X760 GND.t920 GND.t918 GND.t920 GND.t919 nfet_03v3 ad=0.22p pd=1.88u as=0 ps=0 w=0.5u l=4u
X761 B04_OTA_bias_ratio_025_0.Vbias1 B04_OTA_bias_ratio_025_0.Vbias2 a_2910_n11110# GND.t243 nfet_03v3 ad=0.44p pd=2.88u as=0.44p ps=2.88u w=1u l=4u
X762 B04_OTA_3.Vin- a_32752_6250# cap_mim_2f0_m4m5_noshield c_width=10u c_length=10u
X763 B04_OTA_4.Vin- a_32752_n13750# cap_mim_2f0_m4m5_noshield c_width=10u c_length=10u
X764 a_37054_n1694# B04_OTA_4.Vbias3 a_38016_n2762# VDD.t8 pfet_03v3 ad=1.1p pd=5.88u as=1.1p ps=5.88u w=2.5u l=4u
X765 a_32706_3298# VDD05.t52 a_33604_1516# VDD.t3 pfet_03v3 ad=0.22p pd=1.88u as=0.13p ps=1.02u w=0.5u l=1u
X766 a_27346_n2762# a_26384_n1694# VDD.t376 VDD.t135 pfet_03v3 ad=1.1p pd=5.88u as=1.1p ps=5.88u w=2.5u l=4u
X767 GND.t503 GND.t504 cap_mim_2f0_m4m5_noshield c_width=10u c_length=10u
X768 B04_OTA_3.Vin- a_31752_6250# cap_mim_2f0_m4m5_noshield c_width=10u c_length=10u
X769 VDD.t277 VDD.t275 VDD.t277 VDD.t276 pfet_03v3 ad=1.1p pd=5.88u as=0 ps=0 w=2.5u l=4u
X770 B04_OTA_7.Vin+ a_20752_6250# cap_mim_2f0_m4m5_noshield c_width=10u c_length=10u
X771 B04_OTA_7.Vin+ a_20752_6250# cap_mim_2f0_m4m5_noshield c_width=10u c_length=10u
X772 a_984_n2762# VDD05.t45 a_696_n2762# VDD.t42 pfet_03v3 ad=0.13p pd=1.02u as=0.13p ps=1.02u w=0.5u l=1u
X773 GND.t669 GND.t670 cap_mim_2f0_m4m5_noshield c_width=10u c_length=10u
X774 a_22036_3298# VDD05.t62 a_22324_3298# VDD.t33 pfet_03v3 ad=0.13p pd=1.02u as=0.13p ps=1.02u w=0.5u l=1u
X775 VDD.t173 B04_OTA_bias_ratio_025_0.Vbias0 a_696_n2762# VDD.t172 pfet_03v3 ad=1.1p pd=5.88u as=0.65p ps=3.02u w=2.5u l=4u
X776 B04_OTA_4.Vin- a_32752_n13750# cap_mim_2f0_m4m5_noshield c_width=10u c_length=10u
X777 a_696_n2762# B04_OTA_7.Vin+ a_1594_n4544# VDD.t47 pfet_03v3 ad=0.22p pd=1.88u as=0.13p ps=1.02u w=0.5u l=1u
X778 B04_OTA_bias_ratio_5_0.Vbias0 B04_OTA_bias_ratio_5_0.Vbias3 a_48320_n8570# VDD.t190 pfet_03v3 ad=2.2p pd=10.88u as=2.2p ps=10.88u w=5u l=4u
X779 GND.t310 a_1594_1516# a_2344_3630# GND.t306 nfet_03v3 ad=0.22p pd=1.88u as=0.22p ps=1.88u w=0.5u l=4u
X780 B04_OTA_7.Vin+ GND.t81 cap_mim_2f0_m4m5_noshield c_width=10u c_length=10u
X781 B04_OTA_6.Vin- GND.t341 cap_mim_2f0_m4m5_noshield c_width=10u c_length=10u
X782 GND.t157 B04_OTA_bias_ratio_025_1.Vbias1 a_13014_3630# GND.t151 nfet_03v3 ad=0.22p pd=1.88u as=0.22p ps=1.88u w=0.5u l=4u
X783 B04_OTA_3.Vin- B04_OTA_bias_ratio_04_0.Vbias2 a_23684_3630# GND.t58 nfet_03v3 ad=0.22p pd=1.88u as=0.22p ps=1.88u w=0.5u l=4u
X784 GND.t245 a_12264_n4544# a_13014_n2430# GND.t244 nfet_03v3 ad=0.22p pd=1.88u as=0.22p ps=1.88u w=0.5u l=4u
X785 B04_OTA_7.Vin+ a_21752_6250# cap_mim_2f0_m4m5_noshield c_width=10u c_length=10u
X786 B04_OTA_7.Vin+ a_21752_6250# cap_mim_2f0_m4m5_noshield c_width=10u c_length=10u
X787 B04_OTA_3.Vin- a_32752_6250# cap_mim_2f0_m4m5_noshield c_width=10u c_length=10u
X788 GND.t294 B04_OTA_bias_ratio_025_0.Vbias1 a_984_3630# GND.t292 nfet_03v3 ad=0.22p pd=1.88u as=0.22p ps=1.88u w=0.5u l=4u
X789 GND.t316 a_11654_3298# a_11654_3630# GND.t314 nfet_03v3 ad=0.22p pd=1.88u as=0.22p ps=1.88u w=0.5u l=4u
X790 GND.t124 Cap0.t2 a_30752_6250# GND.t123 nfet_03v3 ad=0.22p pd=1.88u as=0.22p ps=1.88u w=0.5u l=1u
X791 GND.t870 GND.t869 GND.t870 GND.t864 nfet_03v3 ad=0.22p pd=1.88u as=0 ps=0 w=0.5u l=4u
X792 GND.t1040 GND.t1038 GND.t1040 GND.t1039 nfet_03v3 ad=0.22p pd=1.88u as=0 ps=0 w=0.5u l=4u
X793 a_6110_n10160# B04_OTA_bias_ratio_025_0.Vbias0 VDD.t175 VDD.t174 pfet_03v3 ad=2.2p pd=10.88u as=2.2p ps=10.88u w=5u l=4u
X794 B04_OTA_6.Vin- a_21752_n13750# cap_mim_2f0_m4m5_noshield c_width=10u c_length=10u
X795 B04_OTA_3.Vin- a_30752_6250# cap_mim_2f0_m4m5_noshield c_width=10u c_length=10u
X796 B04_OTA_6.Vin- GND.t347 cap_mim_2f0_m4m5_noshield c_width=10u c_length=10u
X797 a_22036_3298# B04_OTA_bias_ratio_04_0.Vbias0 VDD.t92 VDD.t91 pfet_03v3 ad=0.65p pd=3.02u as=1.1p ps=5.88u w=2.5u l=4u
X798 a_32994_3298# B04_OTA_3.Vin- a_32706_3298# VDD.t6 pfet_03v3 ad=0.13p pd=1.02u as=0.13p ps=1.02u w=0.5u l=1u
X799 B04_OTA_3.Vin- GND.t8 cap_mim_2f0_m4m5_noshield c_width=10u c_length=10u
X800 GND.t745 GND.t746 cap_mim_2f0_m4m5_noshield c_width=10u c_length=10u
X801 VDD05.t8 B04_OTA_8.Vin- cap_mim_2f0_m4m5_noshield c_width=10u c_length=10u
X802 B04_OTA_4.Vin- GND.t211 cap_mim_2f0_m4m5_noshield c_width=10u c_length=10u
X803 VDD.t243 VDD.t241 VDD.t243 VDD.t242 pfet_03v3 ad=0.22p pd=1.88u as=0 ps=0 w=0.5u l=1u
X804 VDD05.t10 B04_OTA_8.Vin- cap_mim_2f0_m4m5_noshield c_width=10u c_length=10u
X805 GND.t930 GND.t928 GND.t930 GND.t929 nfet_03v3 ad=0.44p pd=2.88u as=0 ps=0 w=1u l=1u
X806 GND.t757 GND.t758 cap_mim_2f0_m4m5_noshield c_width=10u c_length=10u
X807 a_23684_3630# VDD05.t67 a_22036_3298# VDD.t36 pfet_03v3 ad=0.13p pd=1.02u as=0.22p ps=1.88u w=0.5u l=1u
X808 GND.t246 a_12264_n4544# a_12552_n4544# GND.t244 nfet_03v3 ad=0.22p pd=1.88u as=0.22p ps=1.88u w=0.5u l=4u
X809 B04_OTA_6.Vin- a_20752_n13750# cap_mim_2f0_m4m5_noshield c_width=10u c_length=10u
X810 a_1594_1516# Vin.t1 a_696_3298# VDD.t62 pfet_03v3 ad=0.13p pd=1.02u as=0.13p ps=1.02u w=0.5u l=1u
X811 a_23222_1516# a_22934_1516# GND.t174 GND.t171 nfet_03v3 ad=0.22p pd=1.88u as=0.22p ps=1.88u w=0.5u l=4u
X812 B04_OTA_7.Vin+ a_21752_6250# cap_mim_2f0_m4m5_noshield c_width=10u c_length=10u
X813 GND.t779 GND.t780 cap_mim_2f0_m4m5_noshield c_width=10u c_length=10u
X814 B04_OTA_4.Vin- a_31752_n13750# cap_mim_2f0_m4m5_noshield c_width=10u c_length=10u
X815 GND.t799 GND.t800 cap_mim_2f0_m4m5_noshield c_width=10u c_length=10u
X816 a_696_3298# Vin.t4 a_984_3630# VDD.t59 pfet_03v3 ad=0.22p pd=1.88u as=0.13p ps=1.02u w=0.5u l=1u
X817 a_23684_3630# B04_OTA_bias_ratio_04_0.Vbias1 GND.t448 GND.t446 nfet_03v3 ad=0.22p pd=1.88u as=0.22p ps=1.88u w=0.5u l=4u
X818 GND.t400 a_33604_n4544# a_34354_n2430# GND.t399 nfet_03v3 ad=0.22p pd=1.88u as=0.22p ps=1.88u w=0.5u l=4u
X819 B04_OTA_6.Vin- a_21752_n13750# cap_mim_2f0_m4m5_noshield c_width=10u c_length=10u
X820 GND.t134 Cap1.t3 a_20752_6250# GND.t133 nfet_03v3 ad=0.22p pd=1.88u as=0.22p ps=1.88u w=0.5u l=1u
X821 B04_OTA_3.Vin- a_32752_6250# cap_mim_2f0_m4m5_noshield c_width=10u c_length=10u
X822 B04_OTA_6.Vin- GND.t354 cap_mim_2f0_m4m5_noshield c_width=10u c_length=10u
X823 B04_OTA_4.Vin- a_32752_n13750# cap_mim_2f0_m4m5_noshield c_width=10u c_length=10u
X824 B04_OTA_4.Vin- GND.t209 cap_mim_2f0_m4m5_noshield c_width=10u c_length=10u
X825 a_45734_n2430# B04_OTA_8.Vin- a_44086_n2762# VDD.t114 pfet_03v3 ad=0.13p pd=1.02u as=0.22p ps=1.88u w=0.5u l=1u
X826 a_11654_n2430# a_11654_n2762# GND.t268 GND.t265 nfet_03v3 ad=0.22p pd=1.88u as=0.22p ps=1.88u w=0.5u l=4u
X827 B04_OTA_7.Vin+ GND.t85 cap_mim_2f0_m4m5_noshield c_width=10u c_length=10u
X828 B04_OTA_4.Vin- a_31752_n13750# cap_mim_2f0_m4m5_noshield c_width=10u c_length=10u
X829 B04_OTA_3.Vin- a_30752_6250# cap_mim_2f0_m4m5_noshield c_width=10u c_length=10u
X830 GND.t910 GND.t908 GND.t910 GND.t909 nfet_03v3 ad=0.22p pd=1.88u as=0 ps=0 w=0.5u l=4u
X831 a_1882_n4544# a_1594_n4544# GND.t379 GND.t376 nfet_03v3 ad=0.22p pd=1.88u as=0.22p ps=1.88u w=0.5u l=4u
X832 GND.t1085 a_984_3298# a_984_3630# GND.t1083 nfet_03v3 ad=0.22p pd=1.88u as=0.22p ps=1.88u w=0.5u l=4u
X833 VDD.t354 VDD.t353 VDD.t354 VDD.t339 pfet_03v3 ad=1.1p pd=5.88u as=0 ps=0 w=2.5u l=4u
X834 B04_OTA_3.Vin- a_30752_6250# cap_mim_2f0_m4m5_noshield c_width=10u c_length=10u
X835 VDD05.t13 B04_OTA_8.Vin- cap_mim_2f0_m4m5_noshield c_width=10u c_length=10u
X836 VDD.t182 a_15714_n1694# a_15626_n2762# VDD.t143 pfet_03v3 ad=1.1p pd=5.88u as=1.1p ps=5.88u w=2.5u l=4u
X837 VDD.t320 VDD.t318 VDD.t320 VDD.t319 pfet_03v3 ad=1.1p pd=5.88u as=0 ps=0 w=2.5u l=4u
X838 B04_OTA_3.Vin- GND.t6 cap_mim_2f0_m4m5_noshield c_width=10u c_length=10u
X839 B04_OTA_3.Vin- GND.t35 cap_mim_2f0_m4m5_noshield c_width=10u c_length=10u
X840 B04_OTA_4.Vin- a_32752_n13750# cap_mim_2f0_m4m5_noshield c_width=10u c_length=10u
X841 B04_OTA_4.Vbias0 VDD.t391 B04_OTA_4.Vbias3 GND.t414 nfet_03v3 ad=4.4p pd=20.88u as=4.4p ps=20.88u w=10u l=4u
X842 GND.t603 GND.t604 cap_mim_2f0_m4m5_noshield c_width=10u c_length=10u
X843 B04_OTA_7.Vin+ GND.t107 cap_mim_2f0_m4m5_noshield c_width=10u c_length=10u
X844 GND.t1028 GND.t1027 GND.t1028 GND.t1023 nfet_03v3 ad=0.22p pd=1.88u as=0 ps=0 w=0.5u l=4u
X845 GND.t401 a_33604_n4544# a_33892_n4544# GND.t399 nfet_03v3 ad=0.22p pd=1.88u as=0.22p ps=1.88u w=0.5u l=4u
X846 GND.t655 GND.t656 cap_mim_2f0_m4m5_noshield c_width=10u c_length=10u
X847 GND.t896 GND.t895 GND.t896 GND.t890 nfet_03v3 ad=0.22p pd=1.88u as=0 ps=0 w=0.5u l=4u
X848 B04_OTA_4.Vin- a_32752_n13750# cap_mim_2f0_m4m5_noshield c_width=10u c_length=10u
X849 B04_OTA_6.Vin- a_19752_n13750# cap_mim_2f0_m4m5_noshield c_width=10u c_length=10u
X850 GND.t1063 GND.t1061 GND.t1063 GND.t1062 nfet_03v3 ad=0.22p pd=1.88u as=0 ps=0 w=0.5u l=4u
X851 B04_OTA_7.Vin+ a_21752_6250# cap_mim_2f0_m4m5_noshield c_width=10u c_length=10u
X852 B04_OTA_7.Vin+ a_21752_6250# cap_mim_2f0_m4m5_noshield c_width=10u c_length=10u
X853 B04_OTA_6.Vin- GND.t360 cap_mim_2f0_m4m5_noshield c_width=10u c_length=10u
X854 a_984_3630# Vin.t7 a_696_3298# VDD.t56 pfet_03v3 ad=0.13p pd=1.02u as=0.22p ps=1.88u w=0.5u l=1u
X855 a_12552_n4132# a_11654_n2762# GND.t266 GND.t265 nfet_03v3 ad=0.22p pd=1.88u as=0.22p ps=1.88u w=0.5u l=4u
X856 a_45272_n4544# B04_OTA_bias_ratio_5_0.Vbias2 a_44984_n4544# GND.t386 nfet_03v3 ad=0.44p pd=2.88u as=0.44p ps=2.88u w=1u l=1u
X857 VDD05.t3 B04_OTA_8.Vin- cap_mim_2f0_m4m5_noshield c_width=10u c_length=10u
X858 GND.t875 GND.t873 GND.t875 GND.t874 nfet_03v3 ad=0.44p pd=2.88u as=0 ps=0 w=1u l=1u
X859 GND.t597 GND.t598 cap_mim_2f0_m4m5_noshield c_width=10u c_length=10u
X860 B04_OTA_6.Vin- GND.t373 cap_mim_2f0_m4m5_noshield c_width=10u c_length=10u
X861 VDD.t388 B04_OTA_bias_ratio_025_1.Vbias0 a_11366_n2762# VDD.t387 pfet_03v3 ad=1.1p pd=5.88u as=0.65p ps=3.02u w=2.5u l=4u
X862 a_2344_n2430# a_1594_n4544# GND.t377 GND.t376 nfet_03v3 ad=0.22p pd=1.88u as=0.22p ps=1.88u w=0.5u l=4u
X863 B04_OTA_bias_ratio_025_1.Vbias0 VDD.t393 B04_OTA_bias_ratio_025_1.Vbias3 GND.t412 nfet_03v3 ad=4.4p pd=20.88u as=4.4p ps=20.88u w=10u l=4u
X864 B04_OTA_4.Vin- a_32752_n13750# cap_mim_2f0_m4m5_noshield c_width=10u c_length=10u
X865 a_11366_n2762# VDD05.t36 a_12264_n4544# VDD.t71 pfet_03v3 ad=0.22p pd=1.88u as=0.13p ps=1.02u w=0.5u l=1u
X866 B04_OTA_7.Vin+ GND.t83 cap_mim_2f0_m4m5_noshield c_width=10u c_length=10u
X867 VDD.t220 VDD.t218 VDD.t220 VDD.t219 pfet_03v3 ad=1.1p pd=5.88u as=0 ps=0 w=2.5u l=4u
X868 a_32994_3630# VDD05.t59 a_32706_3298# VDD.t4 pfet_03v3 ad=0.13p pd=1.02u as=0.22p ps=1.88u w=0.5u l=1u
X869 a_24250_n11090# B04_OTA_bias_ratio_04_0.Vbias1 GND.t455 GND.t454 nfet_03v3 ad=0.44p pd=2.88u as=0.44p ps=2.88u w=1u l=4u
X870 B04_OTA_7.Vin+ GND.t118 cap_mim_2f0_m4m5_noshield c_width=10u c_length=10u
X871 B04_OTA_4.Vin- GND.t185 cap_mim_2f0_m4m5_noshield c_width=10u c_length=10u
X872 VDD05.t15 B04_OTA_8.Vin- cap_mim_2f0_m4m5_noshield c_width=10u c_length=10u
X873 VDD.t11 a_37054_n1694# a_36966_n2762# VDD.t10 pfet_03v3 ad=1.1p pd=5.88u as=1.1p ps=5.88u w=2.5u l=4u
X874 GND.t1024 GND.t1022 GND.t1024 GND.t1023 nfet_03v3 ad=0.22p pd=1.88u as=0 ps=0 w=0.5u l=4u
X875 B04_OTA_3.Vin- GND.t33 cap_mim_2f0_m4m5_noshield c_width=10u c_length=10u
X876 GND.t583 GND.t584 cap_mim_2f0_m4m5_noshield c_width=10u c_length=10u
X877 GND.t807 GND.t808 cap_mim_2f0_m4m5_noshield c_width=10u c_length=10u
X878 a_11654_3298# B04_OTA_bias_ratio_025_1.Vbias2 a_12552_1928# GND.t251 nfet_03v3 ad=0.44p pd=2.88u as=0.44p ps=2.88u w=1u l=1u
X879 B04_OTA_6.Vin- a_19752_n13750# cap_mim_2f0_m4m5_noshield c_width=10u c_length=10u
X880 GND.t881 GND.t879 GND.t881 GND.t880 nfet_03v3 ad=0.22p pd=1.88u as=0 ps=0 w=0.5u l=4u
X881 GND.t303 B04_OTA_bias_ratio_025_0.Vbias1 a_2344_n2430# GND.t298 nfet_03v3 ad=0.22p pd=1.88u as=0.22p ps=1.88u w=0.5u l=4u
X882 GND.t821 GND.t822 cap_mim_2f0_m4m5_noshield c_width=10u c_length=10u
X883 a_22036_n2762# VDD05.t34 a_23684_n2430# VDD.t73 pfet_03v3 ad=0.13p pd=1.02u as=0.13p ps=1.02u w=0.5u l=1u
X884 B04_OTA_bias_ratio_025_0.Vbias0 B04_OTA_bias_ratio_025_0.Vbias3 a_6110_n10160# VDD.t389 pfet_03v3 ad=2.2p pd=10.88u as=2.2p ps=10.88u w=5u l=4u
X885 B04_OTA_4.Vin- GND.t183 cap_mim_2f0_m4m5_noshield c_width=10u c_length=10u
X886 B04_OTA_3.Vin- a_32752_6250# cap_mim_2f0_m4m5_noshield c_width=10u c_length=10u
X887 GND.t878 GND.t876 GND.t878 GND.t877 nfet_03v3 ad=0.44p pd=2.88u as=0 ps=0 w=1u l=1u
X888 GND.t126 Cap0.t0 a_30752_n13750# GND.t125 nfet_03v3 ad=0.22p pd=1.88u as=0.22p ps=1.88u w=0.5u l=1u
X889 a_22324_n2430# B04_OTA_bias_ratio_04_0.Vbias1 GND.t453 GND.t451 nfet_03v3 ad=0.22p pd=1.88u as=0.22p ps=1.88u w=0.5u l=4u
X890 B04_OTA_4.Vin- GND.t214 cap_mim_2f0_m4m5_noshield c_width=10u c_length=10u
X891 VDD.t111 B04_OTA_4.Vbias0 a_32706_n2762# VDD.t110 pfet_03v3 ad=1.1p pd=5.88u as=0.65p ps=3.02u w=2.5u l=4u
X892 VDD.t372 VDD.t371 VDD.t372 VDD.t356 pfet_03v3 ad=1.1p pd=5.88u as=0 ps=0 w=2.5u l=4u
X893 a_22036_3298# VDD05.t60 a_22324_3298# VDD.t35 pfet_03v3 ad=0.22p pd=1.88u as=0.13p ps=1.02u w=0.5u l=1u
X894 a_32994_3630# B04_OTA_4.Vbias2 a_37054_4366# GND.t273 nfet_03v3 ad=0.22p pd=1.88u as=0.22p ps=1.88u w=0.5u l=4u
X895 a_32706_n2762# VDD05.t20 a_33604_n4544# VDD.t87 pfet_03v3 ad=0.22p pd=1.88u as=0.13p ps=1.02u w=0.5u l=1u
X896 GND.t1037 GND.t1035 GND.t1037 GND.t1036 nfet_03v3 ad=0.22p pd=1.88u as=0 ps=0 w=0.5u l=4u
X897 GND.t291 VbiasN.t0 B04_OTA_bias_ratio_5_0.Vbias3 GND.t290 nfet_03v3 ad=22p pd=0.10088m as=22p ps=0.10088m w=50u l=4u
X898 VDD.t230 VDD.t229 VDD.t230 VDD.t225 pfet_03v3 ad=0.22p pd=1.88u as=0 ps=0 w=0.5u l=1u
X899 GND.t1018 GND.t1017 GND.t1018 GND.t1007 nfet_03v3 ad=0.44p pd=2.88u as=0 ps=0 w=1u l=1u
X900 a_38120_n10140# B04_OTA_4.Vbias0 VDD.t103 VDD.t102 pfet_03v3 ad=2.2p pd=10.88u as=2.2p ps=10.88u w=5u l=4u
X901 B04_OTA_3.Vin- GND.t38 cap_mim_2f0_m4m5_noshield c_width=10u c_length=10u
X902 B04_OTA_4.Vin- a_31752_n13750# cap_mim_2f0_m4m5_noshield c_width=10u c_length=10u
X903 B04_OTA_4.Vin- a_32752_n13750# cap_mim_2f0_m4m5_noshield c_width=10u c_length=10u
X904 GND.t299 B04_OTA_bias_ratio_025_0.Vbias1 a_984_n2430# GND.t298 nfet_03v3 ad=0.22p pd=1.88u as=0.22p ps=1.88u w=0.5u l=4u
X905 GND.t663 GND.t664 cap_mim_2f0_m4m5_noshield c_width=10u c_length=10u
X906 B04_OTA_7.Vin+ GND.t112 cap_mim_2f0_m4m5_noshield c_width=10u c_length=10u
X907 B04_OTA_7.Vin+ GND.t116 cap_mim_2f0_m4m5_noshield c_width=10u c_length=10u
X908 B04_OTA_4.Vin- GND.t212 cap_mim_2f0_m4m5_noshield c_width=10u c_length=10u
X909 B04_OTA_3.Vin- a_31752_6250# cap_mim_2f0_m4m5_noshield c_width=10u c_length=10u
X910 B04_OTA_7.Vin+ a_20752_6250# cap_mim_2f0_m4m5_noshield c_width=10u c_length=10u
X911 GND.t733 GND.t734 cap_mim_2f0_m4m5_noshield c_width=10u c_length=10u
X912 GND.t1060 GND.t1058 GND.t1060 GND.t1059 nfet_03v3 ad=0.44p pd=2.88u as=0 ps=0 w=1u l=1u
X913 B04_OTA_6.Vin- a_21752_n13750# cap_mim_2f0_m4m5_noshield c_width=10u c_length=10u
X914 GND.t677 GND.t678 cap_mim_2f0_m4m5_noshield c_width=10u c_length=10u
X915 GND.t933 GND.t931 GND.t933 GND.t932 nfet_03v3 ad=0.22p pd=1.88u as=0 ps=0 w=0.5u l=4u
X916 B04_OTA_4.Vin- a_31752_n13750# cap_mim_2f0_m4m5_noshield c_width=10u c_length=10u
X917 B04_OTA_6.Vin- a_20752_n13750# cap_mim_2f0_m4m5_noshield c_width=10u c_length=10u
X918 B04_OTA_3.Vin- B04_OTA_bias_ratio_04_0.Vbias3 a_26296_3298# VDD.t130 pfet_03v3 ad=1.1p pd=5.88u as=1.1p ps=5.88u w=2.5u l=4u
X919 a_23684_n2430# B04_OTA_bias_ratio_04_0.Vbias1 GND.t452 GND.t451 nfet_03v3 ad=0.22p pd=1.88u as=0.22p ps=1.88u w=0.5u l=4u
X920 B04_OTA_7.Vin+ a_21752_6250# cap_mim_2f0_m4m5_noshield c_width=10u c_length=10u
X921 GND.t547 GND.t548 cap_mim_2f0_m4m5_noshield c_width=10u c_length=10u
X922 B04_OTA_7.Vin+ a_21752_6250# cap_mim_2f0_m4m5_noshield c_width=10u c_length=10u
X923 B04_OTA_3.Vin- a_32752_6250# cap_mim_2f0_m4m5_noshield c_width=10u c_length=10u
X924 B04_OTA_6.Vin- GND.t324 cap_mim_2f0_m4m5_noshield c_width=10u c_length=10u
X925 a_44086_n2762# B04_OTA_8.Vin- a_44374_n2762# VDD.t119 pfet_03v3 ad=0.13p pd=1.02u as=0.13p ps=1.02u w=0.5u l=1u
X926 GND.t751 GND.t752 cap_mim_2f0_m4m5_noshield c_width=10u c_length=10u
X927 B04_OTA_4.Vin- a_32752_n13750# cap_mim_2f0_m4m5_noshield c_width=10u c_length=10u
X928 Vout.t7 Vout.t6 B04_OTA_8.Vin- B04_OTA_8.Vin- pfet_03v3 ad=0.22p pd=1.88u as=0.22p ps=1.88u w=0.5u l=4u
X929 a_22324_n2430# B04_OTA_6.Vin- a_22036_n2762# VDD.t78 pfet_03v3 ad=0.13p pd=1.02u as=0.13p ps=1.02u w=0.5u l=1u
X930 a_1594_1516# B04_OTA_bias_ratio_025_0.Vbias2 a_1882_1516# GND.t232 nfet_03v3 ad=0.44p pd=2.88u as=0.44p ps=2.88u w=1u l=1u
X931 a_23684_3630# VDD05.t65 a_22036_3298# VDD.t38 pfet_03v3 ad=0.13p pd=1.02u as=0.13p ps=1.02u w=0.5u l=1u
X932 GND.t147 a_22324_3298# a_23222_1928# GND.t143 nfet_03v3 ad=0.22p pd=1.88u as=0.22p ps=1.88u w=0.5u l=4u
X933 B04_OTA_3.Vin- GND.t36 cap_mim_2f0_m4m5_noshield c_width=10u c_length=10u
X934 GND.t914 GND.t913 GND.t914 GND.t903 nfet_03v3 ad=0.44p pd=2.88u as=0 ps=0 w=1u l=1u
X935 a_11654_n2430# VDD05.t43 a_11366_n2762# VDD.t64 pfet_03v3 ad=0.13p pd=1.02u as=0.22p ps=1.88u w=0.5u l=1u
X936 GND.t541 GND.t542 cap_mim_2f0_m4m5_noshield c_width=10u c_length=10u
X937 a_11366_n2762# B04_OTA_6.Vin- a_13014_n2430# VDD.t69 pfet_03v3 ad=0.13p pd=1.02u as=0.13p ps=1.02u w=0.5u l=1u
X938 GND.t585 GND.t586 cap_mim_2f0_m4m5_noshield c_width=10u c_length=10u
X939 VDD.t352 VDD.t351 VDD.t352 VDD.t336 pfet_03v3 ad=1.1p pd=5.88u as=0 ps=0 w=2.5u l=4u
X940 VDD05.t0 B04_OTA_8.Vin- cap_mim_2f0_m4m5_noshield c_width=10u c_length=10u
X941 a_11654_3630# VDD05.t75 a_11366_3298# VDD.t28 pfet_03v3 ad=0.13p pd=1.02u as=0.22p ps=1.88u w=0.5u l=1u
X942 a_696_n2762# B04_OTA_bias_ratio_025_0.Vbias0 VDD.t171 VDD.t170 pfet_03v3 ad=0.65p pd=3.02u as=1.1p ps=5.88u w=2.5u l=4u
X943 VDD.t317 VDD.t315 VDD.t317 VDD.t316 pfet_03v3 ad=1.1p pd=5.88u as=0 ps=0 w=2.5u l=4u
X944 GND.t1005 GND.t1003 GND.t1005 GND.t1004 nfet_03v3 ad=0.44p pd=2.88u as=0 ps=0 w=1u l=1u
X945 a_2344_3630# B04_OTA_bias_ratio_025_0.Vbias2 B04_OTA_7.Vin+ GND.t236 nfet_03v3 ad=0.22p pd=1.88u as=0.22p ps=1.88u w=0.5u l=4u
X946 a_13570_n11110# B04_OTA_bias_ratio_025_1.Vbias1 GND.t154 GND.t153 nfet_03v3 ad=0.44p pd=2.88u as=0.44p ps=2.88u w=1u l=4u
X947 B04_OTA_4.Vin- a_32752_n13750# cap_mim_2f0_m4m5_noshield c_width=10u c_length=10u
X948 B04_OTA_6.Vin- a_19752_n13750# cap_mim_2f0_m4m5_noshield c_width=10u c_length=10u
X949 VDD.t248 VDD.t247 VDD.t248 VDD.t242 pfet_03v3 ad=0.22p pd=1.88u as=0 ps=0 w=0.5u l=1u
X950 B04_OTA_6.Vin- GND.t330 cap_mim_2f0_m4m5_noshield c_width=10u c_length=10u
X951 a_33892_n4544# a_33604_n4544# GND.t404 GND.t402 nfet_03v3 ad=0.22p pd=1.88u as=0.22p ps=1.88u w=0.5u l=4u
X952 GND.t527 GND.t528 cap_mim_2f0_m4m5_noshield c_width=10u c_length=10u
X953 a_22934_1516# B04_OTA_7.Vin+ a_22036_3298# VDD.t36 pfet_03v3 ad=0.13p pd=1.02u as=0.22p ps=1.88u w=0.5u l=1u
X954 VDD05.t16 B04_OTA_8.Vin- cap_mim_2f0_m4m5_noshield c_width=10u c_length=10u
X955 VDD.t326 VDD.t324 VDD.t326 VDD.t325 pfet_03v3 ad=0.22p pd=1.88u as=0 ps=0 w=0.5u l=1u
X956 B04_OTA_7.Vin+ a_21752_6250# cap_mim_2f0_m4m5_noshield c_width=10u c_length=10u
X957 B04_OTA_4.Vin- GND.t188 cap_mim_2f0_m4m5_noshield c_width=10u c_length=10u
X958 GND.t637 GND.t638 cap_mim_2f0_m4m5_noshield c_width=10u c_length=10u
X959 a_49396_n2762# a_48434_n1694# VDD.t193 VDD.t187 pfet_03v3 ad=1.1p pd=5.88u as=1.1p ps=5.88u w=2.5u l=4u
X960 GND.t162 B04_OTA_bias_ratio_025_1.Vbias1 a_13014_n2430# GND.t149 nfet_03v3 ad=0.22p pd=1.88u as=0.22p ps=1.88u w=0.5u l=4u
X961 B04_OTA_6.Vin- a_21752_n13750# cap_mim_2f0_m4m5_noshield c_width=10u c_length=10u
X962 a_696_3298# VDD05.t76 a_984_3298# VDD.t59 pfet_03v3 ad=0.22p pd=1.88u as=0.13p ps=1.02u w=0.5u l=1u
X963 B04_OTA_7.Vin+ B04_OTA_bias_ratio_025_0.Vbias2 a_2344_3630# GND.t233 nfet_03v3 ad=0.22p pd=1.88u as=0.22p ps=1.88u w=0.5u l=4u
X964 a_34354_3630# B04_OTA_4.Vbias2 B04_OTA_7.Vin+ GND.t274 nfet_03v3 ad=0.22p pd=1.88u as=0.22p ps=1.88u w=0.5u l=4u
X965 B04_OTA_4.Vin- a_32752_n13750# cap_mim_2f0_m4m5_noshield c_width=10u c_length=10u
X966 VDD.t254 VDD.t253 VDD.t254 VDD.t239 pfet_03v3 ad=1.1p pd=5.88u as=0 ps=0 w=2.5u l=4u
X967 VDD.t363 VDD.t361 VDD.t363 VDD.t362 pfet_03v3 ad=0.22p pd=1.88u as=0 ps=0 w=0.5u l=1u
X968 B04_OTA_3.Vin- GND.t21 cap_mim_2f0_m4m5_noshield c_width=10u c_length=10u
X969 B04_OTA_3.Vin- GND.t47 cap_mim_2f0_m4m5_noshield c_width=10u c_length=10u
X970 a_32994_3630# B04_OTA_4.Vbias1 GND.t437 GND.t435 nfet_03v3 ad=0.22p pd=1.88u as=0.22p ps=1.88u w=0.5u l=4u
X971 VDD.t94 B04_OTA_bias_ratio_04_0.Vbias0 a_22036_3298# VDD.t93 pfet_03v3 ad=1.1p pd=5.88u as=0.65p ps=3.02u w=2.5u l=4u
X972 B04_OTA_7.Vin+ a_19752_6250# cap_mim_2f0_m4m5_noshield c_width=10u c_length=10u
X973 GND.t707 GND.t708 cap_mim_2f0_m4m5_noshield c_width=10u c_length=10u
X974 a_33892_1928# a_32994_3298# GND.t1 GND.t0 nfet_03v3 ad=0.22p pd=1.88u as=0.22p ps=1.88u w=0.5u l=4u
X975 GND.t289 VbiasN.t2 B04_OTA_bias_ratio_04_0.Vbias3 GND.t288 nfet_03v3 ad=1.76p pd=8.88u as=1.76p ps=8.88u w=4u l=4u
X976 B04_OTA_4.Vin- GND.t186 cap_mim_2f0_m4m5_noshield c_width=10u c_length=10u
X977 B04_OTA_6.Vin- a_19752_n13750# cap_mim_2f0_m4m5_noshield c_width=10u c_length=10u
X978 a_34354_n2430# a_33604_n4544# GND.t403 GND.t402 nfet_03v3 ad=0.22p pd=1.88u as=0.22p ps=1.88u w=0.5u l=4u
X979 GND.t493 GND.t494 cap_mim_2f0_m4m5_noshield c_width=10u c_length=10u
X980 B04_OTA_4.Vin- GND.t217 cap_mim_2f0_m4m5_noshield c_width=10u c_length=10u
X981 B04_OTA_6.Vin- GND.t366 cap_mim_2f0_m4m5_noshield c_width=10u c_length=10u
X982 B04_OTA_bias_ratio_025_1.Vbias1 GND.t1090 B04_OTA_bias_ratio_025_1.Vbias2 VDD.t100 pfet_03v3 ad=2.2p pd=10.88u as=2.2p ps=10.88u w=5u l=4u
X983 B04_OTA_7.Vin+ GND.t99 cap_mim_2f0_m4m5_noshield c_width=10u c_length=10u
X984 a_32706_3298# VDD05.t56 a_32994_3630# VDD.t7 pfet_03v3 ad=0.22p pd=1.88u as=0.13p ps=1.02u w=0.5u l=1u
X985 Vout.t4 B04_OTA_bias_ratio_5_0.Vbias2 a_45734_n2430# GND.t388 nfet_03v3 ad=0.22p pd=1.88u as=0.22p ps=1.88u w=0.5u l=4u
X986 B04_OTA_6.Vin- GND.t357 cap_mim_2f0_m4m5_noshield c_width=10u c_length=10u
X987 VDD.t246 VDD.t244 VDD.t246 VDD.t245 pfet_03v3 ad=0.22p pd=1.88u as=0 ps=0 w=0.5u l=1u
X988 GND.t150 B04_OTA_bias_ratio_025_1.Vbias1 a_11654_n2430# GND.t149 nfet_03v3 ad=0.22p pd=1.88u as=0.22p ps=1.88u w=0.5u l=4u
X989 B04_OTA_7.Vin+ a_21752_6250# cap_mim_2f0_m4m5_noshield c_width=10u c_length=10u
X990 GND.t789 GND.t790 cap_mim_2f0_m4m5_noshield c_width=10u c_length=10u
X991 VDD05.t4 B04_OTA_8.Vin- cap_mim_2f0_m4m5_noshield c_width=10u c_length=10u
X992 GND.t753 GND.t754 cap_mim_2f0_m4m5_noshield c_width=10u c_length=10u
X993 B04_OTA_6.Vin- GND.t352 cap_mim_2f0_m4m5_noshield c_width=10u c_length=10u
X994 a_2344_3630# VDD05.t83 a_696_3298# VDD.t60 pfet_03v3 ad=0.13p pd=1.02u as=0.22p ps=1.88u w=0.5u l=1u
X995 B04_OTA_4.Vbias0 B04_OTA_4.Vbias3 a_38120_n10140# VDD.t88 pfet_03v3 ad=2.2p pd=10.88u as=2.2p ps=10.88u w=5u l=4u
X996 B04_OTA_7.Vin+ a_20752_6250# cap_mim_2f0_m4m5_noshield c_width=10u c_length=10u
X997 VDD05.t6 B04_OTA_8.Vin- cap_mim_2f0_m4m5_noshield c_width=10u c_length=10u
X998 GND.t633 GND.t634 cap_mim_2f0_m4m5_noshield c_width=10u c_length=10u
X999 a_984_3298# VDD05.t79 a_696_3298# VDD.t56 pfet_03v3 ad=0.13p pd=1.02u as=0.22p ps=1.88u w=0.5u l=1u
X1000 a_26384_4366# B04_OTA_bias_ratio_04_0.Vbias2 a_22324_3630# GND.t59 nfet_03v3 ad=0.22p pd=1.88u as=0.22p ps=1.88u w=0.5u l=4u
X1001 a_44984_n4544# B04_OTA_6.Vin- a_44086_n2762# VDD.t114 pfet_03v3 ad=0.13p pd=1.02u as=0.22p ps=1.88u w=0.5u l=1u
X1002 GND.t431 B04_OTA_4.Vbias1 a_34354_n2430# GND.t430 nfet_03v3 ad=0.22p pd=1.88u as=0.22p ps=1.88u w=0.5u l=4u
X1003 B04_OTA_3.Vin- GND.t19 cap_mim_2f0_m4m5_noshield c_width=10u c_length=10u
X1004 B04_OTA_3.Vin- a_32752_6250# cap_mim_2f0_m4m5_noshield c_width=10u c_length=10u
X1005 B04_OTA_6.Vin- a_21752_n13750# cap_mim_2f0_m4m5_noshield c_width=10u c_length=10u
X1006 B04_OTA_4.Vin- a_30752_n13750# cap_mim_2f0_m4m5_noshield c_width=10u c_length=10u
X1007 a_696_n2762# VDD05.t50 a_2344_n2430# VDD.t45 pfet_03v3 ad=0.13p pd=1.02u as=0.13p ps=1.02u w=0.5u l=1u
X1008 B04_OTA_4.Vin- a_31752_n13750# cap_mim_2f0_m4m5_noshield c_width=10u c_length=10u
X1009 a_38016_n2762# a_37054_n1694# VDD.t9 VDD.t8 pfet_03v3 ad=1.1p pd=5.88u as=1.1p ps=5.88u w=2.5u l=4u
X1010 GND.t1000 GND.t999 GND.t1000 GND.t994 nfet_03v3 ad=0.22p pd=1.88u as=0 ps=0 w=0.5u l=4u
X1011 B04_OTA_7.Vin+ a_21752_6250# cap_mim_2f0_m4m5_noshield c_width=10u c_length=10u
X1012 B04_OTA_7.Vin+ a_19752_6250# cap_mim_2f0_m4m5_noshield c_width=10u c_length=10u
X1013 B04_OTA_7.Vin+ a_19752_6250# cap_mim_2f0_m4m5_noshield c_width=10u c_length=10u
X1014 B04_OTA_6.Vin- GND.t368 cap_mim_2f0_m4m5_noshield c_width=10u c_length=10u
X1015 a_32994_3298# B04_OTA_3.Vin- a_32706_3298# VDD.t4 pfet_03v3 ad=0.13p pd=1.02u as=0.22p ps=1.88u w=0.5u l=1u
X1016 GND.t950 GND.t949 GND.t950 GND.t945 nfet_03v3 ad=0.22p pd=1.88u as=0 ps=0 w=0.5u l=4u
X1017 GND.t575 GND.t576 cap_mim_2f0_m4m5_noshield c_width=10u c_length=10u
X1018 a_984_n2430# B04_OTA_bias_ratio_025_0.Vbias1 GND.t301 GND.t300 nfet_03v3 ad=0.22p pd=1.88u as=0.22p ps=1.88u w=0.5u l=4u
X1019 VDD.t232 VDD.t231 VDD.t232 VDD.t216 pfet_03v3 ad=1.1p pd=5.88u as=0 ps=0 w=2.5u l=4u
X1020 GND.t489 GND.t490 cap_mim_2f0_m4m5_noshield c_width=10u c_length=10u
X1021 B04_OTA_7.Vin+ GND.t101 cap_mim_2f0_m4m5_noshield c_width=10u c_length=10u
X1022 B04_OTA_3.Vin- a_31752_6250# cap_mim_2f0_m4m5_noshield c_width=10u c_length=10u
X1023 B04_OTA_4.Vin- a_30752_n13750# cap_mim_2f0_m4m5_noshield c_width=10u c_length=10u
X1024 GND.t943 GND.t941 GND.t943 GND.t942 nfet_03v3 ad=0.22p pd=1.88u as=0 ps=0 w=0.5u l=4u
X1025 GND.t529 GND.t530 cap_mim_2f0_m4m5_noshield c_width=10u c_length=10u
X1026 GND.t166 a_22934_n4544# a_23684_n2430# GND.t165 nfet_03v3 ad=0.22p pd=1.88u as=0.22p ps=1.88u w=0.5u l=4u
X1027 GND.t440 B04_OTA_4.Vbias1 a_32994_n2430# GND.t430 nfet_03v3 ad=0.22p pd=1.88u as=0.22p ps=1.88u w=0.5u l=4u
X1028 GND.t727 GND.t728 cap_mim_2f0_m4m5_noshield c_width=10u c_length=10u
X1029 GND.t595 GND.t596 cap_mim_2f0_m4m5_noshield c_width=10u c_length=10u
X1030 a_11366_n2762# B04_OTA_bias_ratio_025_1.Vbias0 VDD.t386 VDD.t385 pfet_03v3 ad=0.65p pd=3.02u as=1.1p ps=5.88u w=2.5u l=4u
X1031 Vout.t2 B04_OTA_bias_ratio_5_0.Vbias3 a_48346_n2762# VDD.t186 pfet_03v3 ad=1.1p pd=5.88u as=1.1p ps=5.88u w=2.5u l=4u
X1032 B04_OTA_6.Vin- a_21752_n13750# cap_mim_2f0_m4m5_noshield c_width=10u c_length=10u
X1033 VDD.t49 a_37054_4366# a_36966_3298# VDD.t48 pfet_03v3 ad=1.1p pd=5.88u as=1.1p ps=5.88u w=2.5u l=4u
X1034 a_38016_3298# B04_OTA_4.Vbias3 a_37054_4366# VDD.t54 pfet_03v3 ad=1.1p pd=5.88u as=1.1p ps=5.88u w=2.5u l=4u
X1035 GND.t995 GND.t993 GND.t995 GND.t994 nfet_03v3 ad=0.22p pd=1.88u as=0 ps=0 w=0.5u l=4u
X1036 a_22934_n4544# B04_OTA_bias_ratio_04_0.Vbias2 a_23222_n4544# GND.t63 nfet_03v3 ad=0.44p pd=2.88u as=0.44p ps=2.88u w=1u l=1u
X1037 B04_OTA_4.Vin- GND.t220 cap_mim_2f0_m4m5_noshield c_width=10u c_length=10u
X1038 B04_OTA_4.Vin- a_32752_n13750# cap_mim_2f0_m4m5_noshield c_width=10u c_length=10u
X1039 B04_OTA_6.Vin- a_20752_n13750# cap_mim_2f0_m4m5_noshield c_width=10u c_length=10u
X1040 a_2344_n2430# B04_OTA_bias_ratio_025_0.Vbias1 GND.t302 GND.t300 nfet_03v3 ad=0.22p pd=1.88u as=0.22p ps=1.88u w=0.5u l=4u
X1041 GND.t565 GND.t566 cap_mim_2f0_m4m5_noshield c_width=10u c_length=10u
X1042 B04_OTA_3.Vin- a_32752_6250# cap_mim_2f0_m4m5_noshield c_width=10u c_length=10u
X1043 B04_OTA_4.Vin- GND.t191 cap_mim_2f0_m4m5_noshield c_width=10u c_length=10u
X1044 GND.t938 GND.t937 GND.t938 GND.t926 nfet_03v3 ad=0.44p pd=2.88u as=0 ps=0 w=1u l=1u
X1045 B04_OTA_7.Vin+ a_21752_6250# cap_mim_2f0_m4m5_noshield c_width=10u c_length=10u
X1046 B04_OTA_3.Vin- a_30752_6250# cap_mim_2f0_m4m5_noshield c_width=10u c_length=10u
X1047 B04_OTA_7.Vin+ GND.t110 cap_mim_2f0_m4m5_noshield c_width=10u c_length=10u
X1048 B04_OTA_3.Vin- a_32752_6250# cap_mim_2f0_m4m5_noshield c_width=10u c_length=10u
X1049 GND.t741 GND.t742 cap_mim_2f0_m4m5_noshield c_width=10u c_length=10u
X1050 VDD.t272 VDD.t271 VDD.t272 VDD.t256 pfet_03v3 ad=1.1p pd=5.88u as=0 ps=0 w=2.5u l=4u
X1051 GND.t167 a_22934_n4544# a_23222_n4544# GND.t165 nfet_03v3 ad=0.22p pd=1.88u as=0.22p ps=1.88u w=0.5u l=4u
X1052 B04_OTA_7.Vin+ GND.t78 cap_mim_2f0_m4m5_noshield c_width=10u c_length=10u
X1053 B04_OTA_4.Vin- GND.t225 cap_mim_2f0_m4m5_noshield c_width=10u c_length=10u
X1054 B04_OTA_3.Vin- a_31752_6250# cap_mim_2f0_m4m5_noshield c_width=10u c_length=10u
X1055 a_22036_n2762# B04_OTA_6.Vin- a_22934_n4544# VDD.t73 pfet_03v3 ad=0.13p pd=1.02u as=0.13p ps=1.02u w=0.5u l=1u
X1056 a_45734_n2430# B04_OTA_bias_ratio_5_0.Vbias2 Vout.t5 GND.t391 nfet_03v3 ad=0.22p pd=1.88u as=0.22p ps=1.88u w=0.5u l=4u
X1057 a_12264_1516# B04_OTA_bias_ratio_025_1.Vbias2 a_12552_1516# GND.t251 nfet_03v3 ad=0.44p pd=2.88u as=0.44p ps=2.88u w=1u l=1u
X1058 B04_OTA_7.Vin+ a_21752_6250# cap_mim_2f0_m4m5_noshield c_width=10u c_length=10u
X1059 B04_OTA_6.Vin- GND.t334 cap_mim_2f0_m4m5_noshield c_width=10u c_length=10u
X1060 B04_OTA_4.Vin- GND.t189 cap_mim_2f0_m4m5_noshield c_width=10u c_length=10u
X1061 GND.t872 GND.t871 GND.t872 GND.t867 nfet_03v3 ad=0.22p pd=1.88u as=0 ps=0 w=0.5u l=4u
X1062 a_32706_n2762# B04_OTA_4.Vbias0 VDD.t109 VDD.t108 pfet_03v3 ad=0.65p pd=3.02u as=1.1p ps=5.88u w=2.5u l=4u
X1063 B04_OTA_7.Vin+ GND.t105 cap_mim_2f0_m4m5_noshield c_width=10u c_length=10u
X1064 B04_OTA_4.Vin- GND.t223 cap_mim_2f0_m4m5_noshield c_width=10u c_length=10u
X1065 B04_OTA_6.Vin- a_20752_n13750# cap_mim_2f0_m4m5_noshield c_width=10u c_length=10u
X1066 GND.t180 a_12264_1516# a_13014_3630# GND.t175 nfet_03v3 ad=0.22p pd=1.88u as=0.22p ps=1.88u w=0.5u l=4u
X1067 GND.t952 GND.t951 GND.t952 GND.t237 nfet_03v3 ad=0.44p pd=2.88u as=0 ps=0 w=1u l=1u
X1068 a_11654_3630# VDD05.t73 a_11366_3298# VDD.t30 pfet_03v3 ad=0.13p pd=1.02u as=0.13p ps=1.02u w=0.5u l=1u
X1069 a_22324_n2430# a_22324_n2762# GND.t398 GND.t395 nfet_03v3 ad=0.22p pd=1.88u as=0.22p ps=1.88u w=0.5u l=4u
X1070 B04_OTA_6.Vin- a_20752_n13750# cap_mim_2f0_m4m5_noshield c_width=10u c_length=10u
X1071 GND.t307 a_1594_1516# a_1882_1516# GND.t306 nfet_03v3 ad=0.22p pd=1.88u as=0.22p ps=1.88u w=0.5u l=4u
X1072 GND.t152 B04_OTA_bias_ratio_025_1.Vbias1 a_11654_3630# GND.t151 nfet_03v3 ad=0.22p pd=1.88u as=0.22p ps=1.88u w=0.5u l=4u
X1073 a_16770_n10160# B04_OTA_bias_ratio_025_1.Vbias0 VDD.t384 VDD.t383 pfet_03v3 ad=2.2p pd=10.88u as=2.2p ps=10.88u w=5u l=4u
X1074 GND.t817 GND.t818 cap_mim_2f0_m4m5_noshield c_width=10u c_length=10u
X1075 B04_OTA_7.Vin+ a_21752_6250# cap_mim_2f0_m4m5_noshield c_width=10u c_length=10u
X1076 B04_OTA_3.Vin- GND.t55 cap_mim_2f0_m4m5_noshield c_width=10u c_length=10u
X1077 B04_OTA_3.Vin- a_32752_6250# cap_mim_2f0_m4m5_noshield c_width=10u c_length=10u
X1078 a_13014_3630# B04_OTA_bias_ratio_025_1.Vbias2 B04_OTA_7.Vin+ GND.t255 nfet_03v3 ad=0.22p pd=1.88u as=0.22p ps=1.88u w=0.5u l=4u
X1079 GND.t577 GND.t578 cap_mim_2f0_m4m5_noshield c_width=10u c_length=10u
X1080 a_22934_1516# B04_OTA_7.Vin+ a_22036_3298# VDD.t38 pfet_03v3 ad=0.13p pd=1.02u as=0.13p ps=1.02u w=0.5u l=1u
X1081 GND.t865 GND.t863 GND.t865 GND.t864 nfet_03v3 ad=0.22p pd=1.88u as=0 ps=0 w=0.5u l=4u
X1082 VDD.t286 VDD.t284 VDD.t286 VDD.t285 pfet_03v3 ad=0.22p pd=1.88u as=0 ps=0 w=0.5u l=1u
X1083 VDD.t340 VDD.t338 VDD.t340 VDD.t339 pfet_03v3 ad=1.1p pd=5.88u as=0 ps=0 w=2.5u l=4u
X1084 a_6006_3298# a_5044_4366# VDD.t21 VDD.t20 pfet_03v3 ad=1.1p pd=5.88u as=1.1p ps=5.88u w=2.5u l=4u
X1085 a_4956_3298# B04_OTA_bias_ratio_025_0.Vbias3 B04_OTA_7.Vin+ VDD.t18 pfet_03v3 ad=1.1p pd=5.88u as=1.1p ps=5.88u w=2.5u l=4u
X1086 VDD.t260 VDD.t258 VDD.t260 VDD.t259 pfet_03v3 ad=1.1p pd=5.88u as=0 ps=0 w=2.5u l=4u
X1087 B04_OTA_3.Vin- a_31752_6250# cap_mim_2f0_m4m5_noshield c_width=10u c_length=10u
X1088 B04_OTA_6.Vin- GND.t365 cap_mim_2f0_m4m5_noshield c_width=10u c_length=10u
X1089 B04_OTA_6.Vin- GND.t327 cap_mim_2f0_m4m5_noshield c_width=10u c_length=10u
X1090 B04_OTA_7.Vin+ GND.t72 cap_mim_2f0_m4m5_noshield c_width=10u c_length=10u
X1091 B04_OTA_7.Vin+ GND.t76 cap_mim_2f0_m4m5_noshield c_width=10u c_length=10u
X1092 B04_OTA_6.Vin- GND.t340 cap_mim_2f0_m4m5_noshield c_width=10u c_length=10u
X1093 GND.t120 Cap0.t3 a_19752_6250# GND.t119 nfet_03v3 ad=0.22p pd=1.88u as=0.22p ps=1.88u w=0.5u l=1u
X1094 a_11654_3298# B04_OTA_7.Vin+ a_11366_3298# VDD.t28 pfet_03v3 ad=0.13p pd=1.02u as=0.22p ps=1.88u w=0.5u l=1u
X1095 B04_OTA_3.Vin- GND.t28 cap_mim_2f0_m4m5_noshield c_width=10u c_length=10u
X1096 B04_OTA_4.Vin- a_30752_n13750# cap_mim_2f0_m4m5_noshield c_width=10u c_length=10u
X1097 B04_OTA_7.Vin+ B04_OTA_bias_ratio_025_1.Vbias2 a_13014_3630# GND.t252 nfet_03v3 ad=0.22p pd=1.88u as=0.22p ps=1.88u w=0.5u l=4u
X1098 B04_OTA_6.Vin- GND.t353 cap_mim_2f0_m4m5_noshield c_width=10u c_length=10u
X1099 GND.t729 GND.t730 cap_mim_2f0_m4m5_noshield c_width=10u c_length=10u
X1100 B04_OTA_4.Vin- a_32752_n13750# cap_mim_2f0_m4m5_noshield c_width=10u c_length=10u
X1101 GND.t1070 GND.t1069 GND.t1070 GND.t1059 nfet_03v3 ad=0.44p pd=2.88u as=0 ps=0 w=1u l=1u
X1102 a_34920_n11090# B04_OTA_4.Vbias1 GND.t439 GND.t438 nfet_03v3 ad=0.44p pd=2.88u as=0.44p ps=2.88u w=1u l=4u
X1103 B04_OTA_7.Vin+ a_21752_6250# cap_mim_2f0_m4m5_noshield c_width=10u c_length=10u
X1104 GND.t653 GND.t654 cap_mim_2f0_m4m5_noshield c_width=10u c_length=10u
X1105 B04_OTA_7.Vin+ B04_OTA_bias_ratio_025_0.Vbias3 a_4956_3298# VDD.t16 pfet_03v3 ad=1.1p pd=5.88u as=1.1p ps=5.88u w=2.5u l=4u
X1106 a_36966_3298# B04_OTA_4.Vbias3 B04_OTA_7.Vin+ VDD.t50 pfet_03v3 ad=1.1p pd=5.88u as=1.1p ps=5.88u w=2.5u l=4u
X1107 a_23222_n4132# a_22324_n2762# GND.t396 GND.t395 nfet_03v3 ad=0.22p pd=1.88u as=0.22p ps=1.88u w=0.5u l=4u
X1108 a_22324_n2762# VDD05.t29 a_22036_n2762# VDD.t78 pfet_03v3 ad=0.13p pd=1.02u as=0.13p ps=1.02u w=0.5u l=1u
X1109 B04_OTA_7.Vin+ GND.t103 cap_mim_2f0_m4m5_noshield c_width=10u c_length=10u
X1110 GND.t673 GND.t674 cap_mim_2f0_m4m5_noshield c_width=10u c_length=10u
X1111 a_23684_3630# a_22934_1516# GND.t172 GND.t171 nfet_03v3 ad=0.22p pd=1.88u as=0.22p ps=1.88u w=0.5u l=4u
X1112 a_984_n2430# B04_OTA_7.Vin+ a_696_n2762# VDD.t40 pfet_03v3 ad=0.13p pd=1.02u as=0.22p ps=1.88u w=0.5u l=1u
X1113 VDD.t96 B04_OTA_bias_ratio_04_0.Vbias0 a_22036_n2762# VDD.t95 pfet_03v3 ad=1.1p pd=5.88u as=0.65p ps=3.02u w=2.5u l=4u
X1114 a_23684_n2430# VDD05.t33 a_22036_n2762# VDD.t74 pfet_03v3 ad=0.13p pd=1.02u as=0.13p ps=1.02u w=0.5u l=1u
X1115 a_48346_n2762# B04_OTA_bias_ratio_5_0.Vbias3 Vout.t3 VDD.t189 pfet_03v3 ad=1.1p pd=5.88u as=1.1p ps=5.88u w=2.5u l=4u
X1116 a_34354_n2430# B04_OTA_4.Vbias2 B04_OTA_6.Vin- GND.t280 nfet_03v3 ad=0.22p pd=1.88u as=0.22p ps=1.88u w=0.5u l=4u
X1117 GND.t783 GND.t784 cap_mim_2f0_m4m5_noshield c_width=10u c_length=10u
X1118 B04_OTA_4.Vin- a_30752_n13750# cap_mim_2f0_m4m5_noshield c_width=10u c_length=10u
X1119 GND.t763 GND.t764 cap_mim_2f0_m4m5_noshield c_width=10u c_length=10u
X1120 GND.t539 GND.t540 cap_mim_2f0_m4m5_noshield c_width=10u c_length=10u
X1121 a_11654_n2762# B04_OTA_6.Vin- a_11366_n2762# VDD.t64 pfet_03v3 ad=0.13p pd=1.02u as=0.22p ps=1.88u w=0.5u l=1u
X1122 B04_OTA_3.Vin- GND.t53 cap_mim_2f0_m4m5_noshield c_width=10u c_length=10u
X1123 B04_OTA_3.Vin- a_32752_6250# cap_mim_2f0_m4m5_noshield c_width=10u c_length=10u
X1124 GND.t599 GND.t600 cap_mim_2f0_m4m5_noshield c_width=10u c_length=10u
X1125 B04_OTA_6.Vin- GND.t369 cap_mim_2f0_m4m5_noshield c_width=10u c_length=10u
X1126 VDD.t141 a_26384_4366# a_27346_3298# VDD.t132 pfet_03v3 ad=1.1p pd=5.88u as=1.1p ps=5.88u w=2.5u l=4u
X1127 a_11366_n2762# VDD05.t38 a_12264_n4544# VDD.t69 pfet_03v3 ad=0.13p pd=1.02u as=0.13p ps=1.02u w=0.5u l=1u
X1128 GND.t904 GND.t902 GND.t904 GND.t903 nfet_03v3 ad=0.44p pd=2.88u as=0 ps=0 w=1u l=1u
X1129 GND.t509 GND.t510 cap_mim_2f0_m4m5_noshield c_width=10u c_length=10u
X1130 B04_OTA_3.Vin- a_31752_6250# cap_mim_2f0_m4m5_noshield c_width=10u c_length=10u
X1131 a_32994_n2430# VDD05.t27 a_32706_n2762# VDD.t80 pfet_03v3 ad=0.13p pd=1.02u as=0.22p ps=1.88u w=0.5u l=1u
X1132 a_44374_n2430# B04_OTA_6.Vin- a_44086_n2762# VDD.t120 pfet_03v3 ad=0.13p pd=1.02u as=0.13p ps=1.02u w=0.5u l=1u
X1133 GND.t825 GND.t826 cap_mim_2f0_m4m5_noshield c_width=10u c_length=10u
X1134 a_13014_3630# B04_OTA_7.Vin+ a_11366_3298# VDD.t24 pfet_03v3 ad=0.13p pd=1.02u as=0.22p ps=1.88u w=0.5u l=1u
X1135 B04_OTA_3.Vin- a_31752_6250# cap_mim_2f0_m4m5_noshield c_width=10u c_length=10u
X1136 a_32706_n2762# B04_OTA_4.Vin- a_34354_n2430# VDD.t85 pfet_03v3 ad=0.13p pd=1.02u as=0.13p ps=1.02u w=0.5u l=1u
X1137 a_44086_n2762# B04_OTA_8.Vin- a_45734_n2430# VDD.t117 pfet_03v3 ad=0.22p pd=1.88u as=0.13p ps=1.02u w=0.5u l=1u
X1138 GND.t1016 GND.t1015 GND.t1016 GND.t1004 nfet_03v3 ad=0.44p pd=2.88u as=0 ps=0 w=1u l=1u
X1139 B04_OTA_3.Vin- GND.t26 cap_mim_2f0_m4m5_noshield c_width=10u c_length=10u
X1140 a_32706_3298# B04_OTA_3.Vin- a_32994_3298# VDD.t7 pfet_03v3 ad=0.22p pd=1.88u as=0.13p ps=1.02u w=0.5u l=1u
X1141 VDD.t330 VDD.t329 VDD.t330 VDD.t325 pfet_03v3 ad=0.22p pd=1.88u as=0 ps=0 w=0.5u l=1u
X1142 B04_OTA_4.Vin- GND.t194 cap_mim_2f0_m4m5_noshield c_width=10u c_length=10u
X1143 VDD.t237 VDD.t235 VDD.t237 VDD.t236 pfet_03v3 ad=1.1p pd=5.88u as=0 ps=0 w=2.5u l=4u
X1144 a_26384_4366# B04_OTA_bias_ratio_04_0.Vbias3 a_27346_3298# VDD.t131 pfet_03v3 ad=1.1p pd=5.88u as=1.1p ps=5.88u w=2.5u l=4u
X1145 a_11654_3630# a_11654_3298# GND.t317 GND.t312 nfet_03v3 ad=0.22p pd=1.88u as=0.22p ps=1.88u w=0.5u l=4u
X1146 a_32994_n2430# B04_OTA_4.Vbias1 GND.t441 GND.t428 nfet_03v3 ad=0.22p pd=1.88u as=0.22p ps=1.88u w=0.5u l=4u
X1147 B04_OTA_7.Vin+ GND.t114 cap_mim_2f0_m4m5_noshield c_width=10u c_length=10u
X1148 B04_OTA_7.Vin+ a_20752_6250# cap_mim_2f0_m4m5_noshield c_width=10u c_length=10u
X1149 VDD.t250 VDD.t249 VDD.t250 VDD.t245 pfet_03v3 ad=0.22p pd=1.88u as=0 ps=0 w=0.5u l=1u
X1150 GND.t891 GND.t889 GND.t891 GND.t890 nfet_03v3 ad=0.22p pd=1.88u as=0 ps=0 w=0.5u l=4u
X1151 a_1594_1516# Vin.t3 a_696_3298# VDD.t60 pfet_03v3 ad=0.13p pd=1.02u as=0.22p ps=1.88u w=0.5u l=1u
X1152 a_22036_3298# VDD05.t66 a_23684_3630# VDD.t37 pfet_03v3 ad=0.13p pd=1.02u as=0.13p ps=1.02u w=0.5u l=1u
X1153 VDD.t357 VDD.t355 VDD.t357 VDD.t356 pfet_03v3 ad=1.1p pd=5.88u as=0 ps=0 w=2.5u l=4u
X1154 VDD.t368 VDD.t367 VDD.t368 VDD.t362 pfet_03v3 ad=0.22p pd=1.88u as=0 ps=0 w=0.5u l=1u
X1155 B04_OTA_3.Vin- a_32752_6250# cap_mim_2f0_m4m5_noshield c_width=10u c_length=10u
X1156 B04_OTA_4.Vin- GND.t228 cap_mim_2f0_m4m5_noshield c_width=10u c_length=10u
X1157 B04_OTA_6.Vin- a_20752_n13750# cap_mim_2f0_m4m5_noshield c_width=10u c_length=10u
X1158 GND.t267 a_11654_n2762# a_12552_n4132# GND.t263 nfet_03v3 ad=0.22p pd=1.88u as=0.22p ps=1.88u w=0.5u l=4u
X1159 a_696_3298# Vin.t6 a_984_3630# VDD.t57 pfet_03v3 ad=0.13p pd=1.02u as=0.13p ps=1.02u w=0.5u l=1u
X1160 B04_OTA_7.Vin+ a_21752_6250# cap_mim_2f0_m4m5_noshield c_width=10u c_length=10u
X1161 B04_OTA_4.Vin- GND.t192 cap_mim_2f0_m4m5_noshield c_width=10u c_length=10u
X1162 B04_OTA_7.Vin+ a_19752_6250# cap_mim_2f0_m4m5_noshield c_width=10u c_length=10u
X1163 a_36966_n2762# B04_OTA_4.Vbias3 B04_OTA_6.Vin- VDD.t14 pfet_03v3 ad=1.1p pd=5.88u as=1.1p ps=5.88u w=2.5u l=4u
X1164 B04_OTA_6.Vin- a_21752_n13750# cap_mim_2f0_m4m5_noshield c_width=10u c_length=10u
X1165 GND.t681 GND.t682 cap_mim_2f0_m4m5_noshield c_width=10u c_length=10u
X1166 VDD.t366 VDD.t364 VDD.t366 VDD.t365 pfet_03v3 ad=0.22p pd=1.88u as=0 ps=0 w=0.5u l=1u
X1167 GND.t979 GND.t977 GND.t979 GND.t978 nfet_03v3 ad=0.44p pd=2.88u as=0 ps=0 w=1u l=1u
X1168 B04_OTA_4.Vin- GND.t226 cap_mim_2f0_m4m5_noshield c_width=10u c_length=10u
X1169 B04_OTA_3.Vin- a_30752_6250# cap_mim_2f0_m4m5_noshield c_width=10u c_length=10u
X1170 B04_OTA_3.Vin- GND.t11 cap_mim_2f0_m4m5_noshield c_width=10u c_length=10u
X1171 a_1594_n4544# B04_OTA_bias_ratio_025_0.Vbias2 a_1882_n4544# GND.t238 nfet_03v3 ad=0.44p pd=2.88u as=0.44p ps=2.88u w=1u l=1u
X1172 GND.t130 Cap1.t0 a_31752_n13750# GND.t129 nfet_03v3 ad=0.22p pd=1.88u as=0.22p ps=1.88u w=0.5u l=1u
X1173 a_34354_n2430# B04_OTA_4.Vbias1 GND.t429 GND.t428 nfet_03v3 ad=0.22p pd=1.88u as=0.22p ps=1.88u w=0.5u l=4u
X1174 B04_OTA_7.Vin+ a_20752_6250# cap_mim_2f0_m4m5_noshield c_width=10u c_length=10u
X1175 B04_OTA_4.Vin- a_32752_n13750# cap_mim_2f0_m4m5_noshield c_width=10u c_length=10u
X1176 GND.t858 GND.t856 GND.t858 GND.t857 nfet_03v3 ad=0.22p pd=1.88u as=0 ps=0 w=0.5u l=4u
X1177 B04_OTA_6.Vin- a_21752_n13750# cap_mim_2f0_m4m5_noshield c_width=10u c_length=10u
X1178 GND.t735 GND.t736 cap_mim_2f0_m4m5_noshield c_width=10u c_length=10u
X1179 GND.t715 GND.t716 cap_mim_2f0_m4m5_noshield c_width=10u c_length=10u
X1180 a_34354_3630# B04_OTA_3.Vin- a_32706_3298# VDD.t2 pfet_03v3 ad=0.13p pd=1.02u as=0.13p ps=1.02u w=0.5u l=1u
X1181 B04_OTA_6.Vin- a_20752_n13750# cap_mim_2f0_m4m5_noshield c_width=10u c_length=10u
X1182 VDD.t206 VDD.t204 VDD.t206 VDD.t205 pfet_03v3 ad=0.22p pd=1.88u as=0 ps=0 w=0.5u l=1u
X1183 a_32994_n2430# VDD05.t25 a_32706_n2762# VDD.t82 pfet_03v3 ad=0.13p pd=1.02u as=0.13p ps=1.02u w=0.5u l=1u
X1184 GND.t264 a_11654_n2762# a_11654_n2430# GND.t263 nfet_03v3 ad=0.22p pd=1.88u as=0.22p ps=1.88u w=0.5u l=4u
X1185 GND.t785 GND.t786 cap_mim_2f0_m4m5_noshield c_width=10u c_length=10u
X1186 GND.t819 GND.t820 cap_mim_2f0_m4m5_noshield c_width=10u c_length=10u
X1187 B04_OTA_3.Vin- a_32752_6250# cap_mim_2f0_m4m5_noshield c_width=10u c_length=10u
X1188 B04_OTA_4.Vin- a_32752_n13750# cap_mim_2f0_m4m5_noshield c_width=10u c_length=10u
X1189 a_696_n2762# B04_OTA_7.Vin+ a_1594_n4544# VDD.t45 pfet_03v3 ad=0.13p pd=1.02u as=0.13p ps=1.02u w=0.5u l=1u
X1190 a_22324_n2430# B04_OTA_6.Vin- a_22036_n2762# VDD.t76 pfet_03v3 ad=0.13p pd=1.02u as=0.22p ps=1.88u w=0.5u l=1u
X1191 GND.t601 GND.t602 cap_mim_2f0_m4m5_noshield c_width=10u c_length=10u
X1192 GND.t797 GND.t798 cap_mim_2f0_m4m5_noshield c_width=10u c_length=10u
X1193 B04_OTA_7.Vin+ a_21752_6250# cap_mim_2f0_m4m5_noshield c_width=10u c_length=10u
X1194 B04_OTA_6.Vin- GND.t362 cap_mim_2f0_m4m5_noshield c_width=10u c_length=10u
X1195 a_23222_1516# B04_OTA_bias_ratio_04_0.Vbias2 a_22934_1516# GND.t56 nfet_03v3 ad=0.44p pd=2.88u as=0.44p ps=2.88u w=1u l=1u
X1196 B04_OTA_3.Vin- a_32752_6250# cap_mim_2f0_m4m5_noshield c_width=10u c_length=10u
X1197 GND.t1031 GND.t1029 GND.t1031 GND.t1030 nfet_03v3 ad=0.44p pd=2.88u as=0 ps=0 w=1u l=1u
X1198 B04_OTA_4.Vbias1 B04_OTA_4.Vbias2 a_34920_n11090# GND.t281 nfet_03v3 ad=0.44p pd=2.88u as=0.44p ps=2.88u w=1u l=4u
X1199 a_984_3630# a_984_3298# GND.t1086 GND.t1081 nfet_03v3 ad=0.22p pd=1.88u as=0.22p ps=1.88u w=0.5u l=4u
X1200 VDD.t337 VDD.t335 VDD.t337 VDD.t336 pfet_03v3 ad=1.1p pd=5.88u as=0 ps=0 w=2.5u l=4u
X1201 a_984_n2430# a_984_n2762# GND.t385 GND.t383 nfet_03v3 ad=0.22p pd=1.88u as=0.22p ps=1.88u w=0.5u l=4u
X1202 GND.t1066 GND.t1064 GND.t1066 GND.t1065 nfet_03v3 ad=0.22p pd=1.88u as=0 ps=0 w=0.5u l=4u
X1203 B04_OTA_3.Vin- a_30752_6250# cap_mim_2f0_m4m5_noshield c_width=10u c_length=10u
X1204 B04_OTA_3.Vin- GND.t9 cap_mim_2f0_m4m5_noshield c_width=10u c_length=10u
X1205 GND.t543 GND.t544 cap_mim_2f0_m4m5_noshield c_width=10u c_length=10u
X1206 B04_OTA_6.Vin- a_21752_n13750# cap_mim_2f0_m4m5_noshield c_width=10u c_length=10u
X1207 B04_OTA_4.Vin- a_30752_n13750# cap_mim_2f0_m4m5_noshield c_width=10u c_length=10u
X1208 VDD.t197 VDD.t195 VDD.t197 VDD.t196 pfet_03v3 ad=1.1p pd=5.88u as=0 ps=0 w=2.5u l=4u
X1209 B04_OTA_7.Vin+ a_20752_6250# cap_mim_2f0_m4m5_noshield c_width=10u c_length=10u
X1210 B04_OTA_7.Vin+ a_20752_6250# cap_mim_2f0_m4m5_noshield c_width=10u c_length=10u
X1211 VDD.t346 VDD.t344 VDD.t346 VDD.t345 pfet_03v3 ad=0.22p pd=1.88u as=0 ps=0 w=0.5u l=1u
X1212 GND.t443 B04_OTA_bias_ratio_04_0.Vbias1 a_23684_n2430# GND.t442 nfet_03v3 ad=0.22p pd=1.88u as=0.22p ps=1.88u w=0.5u l=4u
X1213 GND.t1054 GND.t1053 GND.t1054 GND.t1049 nfet_03v3 ad=0.22p pd=1.88u as=0 ps=0 w=0.5u l=4u
X1214 GND.t675 GND.t676 cap_mim_2f0_m4m5_noshield c_width=10u c_length=10u
X1215 GND.t381 a_984_n2762# a_1882_n4132# GND.t380 nfet_03v3 ad=0.22p pd=1.88u as=0.22p ps=1.88u w=0.5u l=4u
X1216 GND.t563 GND.t564 cap_mim_2f0_m4m5_noshield c_width=10u c_length=10u
X1217 GND.t831 GND.t832 cap_mim_2f0_m4m5_noshield c_width=10u c_length=10u
X1218 a_16676_3298# a_15714_4366# VDD.t127 VDD.t126 pfet_03v3 ad=1.1p pd=5.88u as=1.1p ps=5.88u w=2.5u l=4u
X1219 a_15626_3298# B04_OTA_bias_ratio_025_1.Vbias3 B04_OTA_7.Vin+ VDD.t128 pfet_03v3 ad=1.1p pd=5.88u as=1.1p ps=5.88u w=2.5u l=4u
X1220 B04_OTA_7.Vin+ a_21752_6250# cap_mim_2f0_m4m5_noshield c_width=10u c_length=10u
X1221 a_11654_3298# B04_OTA_7.Vin+ a_11366_3298# VDD.t30 pfet_03v3 ad=0.13p pd=1.02u as=0.13p ps=1.02u w=0.5u l=1u
X1222 B04_OTA_4.Vin- GND.t197 cap_mim_2f0_m4m5_noshield c_width=10u c_length=10u
X1223 B04_OTA_6.Vin- GND.t346 cap_mim_2f0_m4m5_noshield c_width=10u c_length=10u
X1224 GND.t449 B04_OTA_bias_ratio_04_0.Vbias1 a_23684_3630# GND.t444 nfet_03v3 ad=0.22p pd=1.88u as=0.22p ps=1.88u w=0.5u l=4u
X1225 a_1882_n4132# a_984_n2762# GND.t384 GND.t383 nfet_03v3 ad=0.22p pd=1.88u as=0.22p ps=1.88u w=0.5u l=4u
X1226 a_22324_n2762# B04_OTA_bias_ratio_04_0.Vbias2 a_23222_n4132# GND.t63 nfet_03v3 ad=0.44p pd=2.88u as=0.44p ps=2.88u w=1u l=1u
X1227 GND.t322 a_44984_n4544# a_45734_n2430# GND.t318 nfet_03v3 ad=0.22p pd=1.88u as=0.22p ps=1.88u w=0.5u l=4u
X1228 B04_OTA_6.Vin- a_21752_n13750# cap_mim_2f0_m4m5_noshield c_width=10u c_length=10u
X1229 GND.t827 GND.t828 cap_mim_2f0_m4m5_noshield c_width=10u c_length=10u
X1230 B04_OTA_6.Vin- GND.t337 cap_mim_2f0_m4m5_noshield c_width=10u c_length=10u
X1231 GND.t927 GND.t925 GND.t927 GND.t926 nfet_03v3 ad=0.44p pd=2.88u as=0 ps=0 w=1u l=1u
X1232 GND.t144 a_22324_3298# a_22324_3630# GND.t143 nfet_03v3 ad=0.22p pd=1.88u as=0.22p ps=1.88u w=0.5u l=4u
X1233 B04_OTA_7.Vin+ GND.t70 cap_mim_2f0_m4m5_noshield c_width=10u c_length=10u
X1234 GND.t557 GND.t558 cap_mim_2f0_m4m5_noshield c_width=10u c_length=10u
X1235 GND.t773 GND.t774 cap_mim_2f0_m4m5_noshield c_width=10u c_length=10u
X1236 VDD05.t12 B04_OTA_8.Vin- cap_mim_2f0_m4m5_noshield c_width=10u c_length=10u
X1237 B04_OTA_7.Vin+ B04_OTA_bias_ratio_025_1.Vbias3 a_15626_3298# VDD.t124 pfet_03v3 ad=1.1p pd=5.88u as=1.1p ps=5.88u w=2.5u l=4u
X1238 B04_OTA_7.Vin+ a_19752_6250# cap_mim_2f0_m4m5_noshield c_width=10u c_length=10u
X1239 B04_OTA_4.Vin- GND.t201 cap_mim_2f0_m4m5_noshield c_width=10u c_length=10u
X1240 GND.t737 GND.t738 cap_mim_2f0_m4m5_noshield c_width=10u c_length=10u
X1241 GND.t450 B04_OTA_bias_ratio_04_0.Vbias1 a_22324_n2430# GND.t442 nfet_03v3 ad=0.22p pd=1.88u as=0.22p ps=1.88u w=0.5u l=4u
X1242 GND.t1050 GND.t1048 GND.t1050 GND.t1049 nfet_03v3 ad=0.22p pd=1.88u as=0 ps=0 w=0.5u l=4u
X1243 VDD05.t14 B04_OTA_8.Vin- cap_mim_2f0_m4m5_noshield c_width=10u c_length=10u
X1244 GND.t382 a_984_n2762# a_984_n2430# GND.t380 nfet_03v3 ad=0.22p pd=1.88u as=0.22p ps=1.88u w=0.5u l=4u
X1245 a_11366_n2762# VDD05.t40 a_11654_n2430# VDD.t67 pfet_03v3 ad=0.22p pd=1.88u as=0.13p ps=1.02u w=0.5u l=1u
X1246 VDD.t374 VDD.t373 VDD.t374 VDD.t359 pfet_03v3 ad=1.1p pd=5.88u as=0 ps=0 w=2.5u l=4u
X1247 GND.t687 GND.t688 cap_mim_2f0_m4m5_noshield c_width=10u c_length=10u
X1248 B04_OTA_7.Vin+ a_21752_6250# cap_mim_2f0_m4m5_noshield c_width=10u c_length=10u
X1249 B04_OTA_4.Vin- a_31752_n13750# cap_mim_2f0_m4m5_noshield c_width=10u c_length=10u
X1250 B04_OTA_4.Vin- GND.t229 cap_mim_2f0_m4m5_noshield c_width=10u c_length=10u
X1251 B04_OTA_6.Vin- a_21752_n13750# cap_mim_2f0_m4m5_noshield c_width=10u c_length=10u
X1252 B04_OTA_3.Vin- a_32752_6250# cap_mim_2f0_m4m5_noshield c_width=10u c_length=10u
X1253 a_32994_3298# B04_OTA_4.Vbias2 a_33892_1928# GND.t270 nfet_03v3 ad=0.44p pd=2.88u as=0.44p ps=2.88u w=1u l=1u
X1254 a_12264_n4544# B04_OTA_bias_ratio_025_1.Vbias2 a_12552_n4544# GND.t257 nfet_03v3 ad=0.44p pd=2.88u as=0.44p ps=2.88u w=1u l=1u
X1255 B04_OTA_6.Vin- GND.t348 cap_mim_2f0_m4m5_noshield c_width=10u c_length=10u
X1256 a_13014_3630# B04_OTA_7.Vin+ a_11366_3298# VDD.t26 pfet_03v3 ad=0.13p pd=1.02u as=0.13p ps=1.02u w=0.5u l=1u
X1257 a_38016_3298# a_37054_4366# VDD.t53 VDD.t52 pfet_03v3 ad=1.1p pd=5.88u as=1.1p ps=5.88u w=2.5u l=4u
X1258 GND.t319 a_44984_n4544# a_45272_n4544# GND.t318 nfet_03v3 ad=0.22p pd=1.88u as=0.22p ps=1.88u w=0.5u l=4u
X1259 B04_OTA_4.Vin- a_32752_n13750# cap_mim_2f0_m4m5_noshield c_width=10u c_length=10u
X1260 a_1882_1516# B04_OTA_bias_ratio_025_0.Vbias2 a_1594_1516# GND.t231 nfet_03v3 ad=0.44p pd=2.88u as=0.44p ps=2.88u w=1u l=1u
X1261 GND.t963 GND.t962 GND.t963 GND.t237 nfet_03v3 ad=0.44p pd=2.88u as=0 ps=0 w=1u l=1u
X1262 GND.t1026 GND.t1025 GND.t1026 GND.t1020 nfet_03v3 ad=0.22p pd=1.88u as=0 ps=0 w=0.5u l=4u
X1263 a_33892_1516# a_33604_1516# GND.t427 GND.t424 nfet_03v3 ad=0.22p pd=1.88u as=0.22p ps=1.88u w=0.5u l=4u
X1264 VDD.t290 VDD.t289 VDD.t290 VDD.t285 pfet_03v3 ad=0.22p pd=1.88u as=0 ps=0 w=0.5u l=1u
X1265 B04_OTA_4.Vin- a_31752_n13750# cap_mim_2f0_m4m5_noshield c_width=10u c_length=10u
X1266 GND.t683 GND.t684 cap_mim_2f0_m4m5_noshield c_width=10u c_length=10u
X1267 B04_OTA_3.Vin- GND.t41 cap_mim_2f0_m4m5_noshield c_width=10u c_length=10u
X1268 B04_OTA_3.Vin- a_32752_6250# cap_mim_2f0_m4m5_noshield c_width=10u c_length=10u
X1269 a_34354_3630# B04_OTA_4.Vbias1 GND.t436 GND.t435 nfet_03v3 ad=0.22p pd=1.88u as=0.22p ps=1.88u w=0.5u l=4u
X1270 B04_OTA_bias_ratio_5_0.Vbias1 GND.t1087 B04_OTA_bias_ratio_5_0.Vbias2 VDD.t112 pfet_03v3 ad=2.2p pd=10.88u as=2.2p ps=10.88u w=5u l=4u
X1271 GND.t545 GND.t546 cap_mim_2f0_m4m5_noshield c_width=10u c_length=10u
X1272 a_22036_3298# VDD05.t64 a_23684_3630# VDD.t39 pfet_03v3 ad=0.22p pd=1.88u as=0.13p ps=1.02u w=0.5u l=1u
X1273 B04_OTA_4.Vin- a_32752_n13750# cap_mim_2f0_m4m5_noshield c_width=10u c_length=10u
X1274 GND.t631 GND.t632 cap_mim_2f0_m4m5_noshield c_width=10u c_length=10u
X1275 a_12264_1516# VDD05.t71 a_11366_3298# VDD.t24 pfet_03v3 ad=0.13p pd=1.02u as=0.22p ps=1.88u w=0.5u l=1u
X1276 B04_OTA_7.Vin+ GND.t117 cap_mim_2f0_m4m5_noshield c_width=10u c_length=10u
X1277 B04_OTA_6.Vin- a_21752_n13750# cap_mim_2f0_m4m5_noshield c_width=10u c_length=10u
X1278 a_22036_n2762# B04_OTA_bias_ratio_04_0.Vbias0 VDD.t90 VDD.t89 pfet_03v3 ad=0.65p pd=3.02u as=1.1p ps=5.88u w=2.5u l=4u
X1279 GND.t285 VbiasN.t4 B04_OTA_bias_ratio_025_0.Vbias3 GND.t284 nfet_03v3 ad=1.1p pd=5.88u as=1.1p ps=5.88u w=2.5u l=4u
X1280 B04_OTA_3.Vin- a_31752_6250# cap_mim_2f0_m4m5_noshield c_width=10u c_length=10u
X1281 B04_OTA_7.Vin+ a_20752_6250# cap_mim_2f0_m4m5_noshield c_width=10u c_length=10u
X1282 B04_OTA_4.Vin- GND.t200 cap_mim_2f0_m4m5_noshield c_width=10u c_length=10u
X1283 a_11366_3298# VDD05.t74 a_11654_3630# VDD.t29 pfet_03v3 ad=0.13p pd=1.02u as=0.13p ps=1.02u w=0.5u l=1u
X1284 VDD.t192 a_48434_n1694# a_48346_n2762# VDD.t186 pfet_03v3 ad=1.1p pd=5.88u as=1.1p ps=5.88u w=2.5u l=4u
X1285 a_984_n2762# VDD05.t47 a_696_n2762# VDD.t40 pfet_03v3 ad=0.13p pd=1.02u as=0.22p ps=1.88u w=0.5u l=1u
X1286 a_22934_n4544# B04_OTA_6.Vin- a_22036_n2762# VDD.t74 pfet_03v3 ad=0.13p pd=1.02u as=0.13p ps=1.02u w=0.5u l=1u
X1287 GND.t1021 GND.t1019 GND.t1021 GND.t1020 nfet_03v3 ad=0.22p pd=1.88u as=0 ps=0 w=0.5u l=4u
X1288 B04_OTA_7.Vin+ a_21752_6250# cap_mim_2f0_m4m5_noshield c_width=10u c_length=10u
X1289 B04_OTA_7.Vin+ a_21752_6250# cap_mim_2f0_m4m5_noshield c_width=10u c_length=10u
X1290 B04_OTA_3.Vin- a_32752_6250# cap_mim_2f0_m4m5_noshield c_width=10u c_length=10u
X1291 a_33604_n4544# B04_OTA_4.Vbias2 a_33892_n4544# GND.t276 nfet_03v3 ad=0.44p pd=2.88u as=0.44p ps=2.88u w=1u l=1u
X1292 B04_OTA_3.Vin- a_32752_6250# cap_mim_2f0_m4m5_noshield c_width=10u c_length=10u
X1293 B04_OTA_6.Vin- GND.t332 cap_mim_2f0_m4m5_noshield c_width=10u c_length=10u
X1294 a_22036_3298# B04_OTA_7.Vin+ a_22934_1516# VDD.t37 pfet_03v3 ad=0.13p pd=1.02u as=0.13p ps=1.02u w=0.5u l=1u
X1295 GND.t922 GND.t921 GND.t922 GND.t916 nfet_03v3 ad=0.22p pd=1.88u as=0 ps=0 w=0.5u l=4u
X1296 B04_OTA_6.Vin- GND.t363 cap_mim_2f0_m4m5_noshield c_width=10u c_length=10u
X1297 a_696_3298# VDD05.t78 a_984_3298# VDD.t57 pfet_03v3 ad=0.13p pd=1.02u as=0.13p ps=1.02u w=0.5u l=1u
X1298 GND.t487 GND.t488 cap_mim_2f0_m4m5_noshield c_width=10u c_length=10u
X1299 GND.t884 GND.t882 GND.t884 GND.t883 nfet_03v3 ad=0.22p pd=1.88u as=0 ps=0 w=0.5u l=4u
X1300 a_2344_n2430# B04_OTA_bias_ratio_025_0.Vbias2 B04_OTA_6.Vin- GND.t242 nfet_03v3 ad=0.22p pd=1.88u as=0.22p ps=1.88u w=0.5u l=4u
X1301 B04_OTA_3.Vin- GND.t39 cap_mim_2f0_m4m5_noshield c_width=10u c_length=10u
X1302 a_32994_n2762# B04_OTA_4.Vin- a_32706_n2762# VDD.t80 pfet_03v3 ad=0.13p pd=1.02u as=0.22p ps=1.88u w=0.5u l=1u
X1303 a_44374_n2762# B04_OTA_8.Vin- a_44086_n2762# VDD.t120 pfet_03v3 ad=0.13p pd=1.02u as=0.13p ps=1.02u w=0.5u l=1u
X1304 GND.t791 GND.t792 cap_mim_2f0_m4m5_noshield c_width=10u c_length=10u
X1305 VDD.t23 a_5044_4366# a_6006_3298# VDD.t22 pfet_03v3 ad=1.1p pd=5.88u as=1.1p ps=5.88u w=2.5u l=4u
X1306 VDD.t214 VDD.t213 VDD.t214 VDD.t199 pfet_03v3 ad=1.1p pd=5.88u as=0 ps=0 w=2.5u l=4u
X1307 VDD.t179 B04_OTA_bias_ratio_5_0.Vbias0 a_44086_n2762# VDD.t178 pfet_03v3 ad=1.1p pd=5.88u as=0.65p ps=3.02u w=2.5u l=4u
X1308 GND.t805 GND.t806 cap_mim_2f0_m4m5_noshield c_width=10u c_length=10u
X1309 GND.t837 GND.t838 cap_mim_2f0_m4m5_noshield c_width=10u c_length=10u
X1310 a_22324_3630# B04_OTA_7.Vin+ a_22036_3298# VDD.t34 pfet_03v3 ad=0.13p pd=1.02u as=0.13p ps=1.02u w=0.5u l=1u
X1311 GND.t946 GND.t944 GND.t946 GND.t945 nfet_03v3 ad=0.22p pd=1.88u as=0 ps=0 w=0.5u l=4u
X1312 a_32706_n2762# VDD05.t22 a_33604_n4544# VDD.t85 pfet_03v3 ad=0.13p pd=1.02u as=0.13p ps=1.02u w=0.5u l=1u
X1313 a_44086_n2762# B04_OTA_6.Vin- a_44984_n4544# VDD.t117 pfet_03v3 ad=0.22p pd=1.88u as=0.13p ps=1.02u w=0.5u l=1u
X1314 GND.t591 GND.t592 cap_mim_2f0_m4m5_noshield c_width=10u c_length=10u
X1315 a_696_n2762# B04_OTA_7.Vin+ a_984_n2430# VDD.t43 pfet_03v3 ad=0.22p pd=1.88u as=0.13p ps=1.02u w=0.5u l=1u
X1316 B04_OTA_3.Vin- a_31752_6250# cap_mim_2f0_m4m5_noshield c_width=10u c_length=10u
X1317 B04_OTA_7.Vin+ a_20752_6250# cap_mim_2f0_m4m5_noshield c_width=10u c_length=10u
X1318 B04_OTA_6.Vin- a_19752_n13750# cap_mim_2f0_m4m5_noshield c_width=10u c_length=10u
X1319 a_33604_1516# VDD05.t53 a_32706_3298# VDD.t2 pfet_03v3 ad=0.13p pd=1.02u as=0.13p ps=1.02u w=0.5u l=1u
X1320 a_13014_n2430# B04_OTA_6.Vin- a_11366_n2762# VDD.t70 pfet_03v3 ad=0.13p pd=1.02u as=0.13p ps=1.02u w=0.5u l=1u
X1321 a_45120_n9520# B04_OTA_bias_ratio_5_0.Vbias1 GND.t462 GND.t392 nfet_03v3 ad=0.44p pd=2.88u as=0.44p ps=2.88u w=1u l=4u
X1322 B04_OTA_7.Vin+ GND.t74 cap_mim_2f0_m4m5_noshield c_width=10u c_length=10u
C0 B04_OTA_6.Vin- a_44374_n2430# 0.77755f
C1 B04_OTA_bias_ratio_04_0.Vbias2 a_23684_3630# 0.60984f
C2 a_45272_n4544# a_45734_n2430# 1.1587f
C3 a_6110_n10160# B04_OTA_bias_ratio_025_0.Vbias0 0.5954f
C4 B04_OTA_bias_ratio_04_0.Vbias2 B04_OTA_4.Vin- 0.7947f
C5 B04_OTA_4.Vbias2 a_33892_1516# 0.64528f
C6 a_11654_3630# a_11654_3298# 1.56314f
C7 a_45734_n2430# a_44984_n4544# 1.9351f
C8 B04_OTA_bias_ratio_04_0.Vbias2 a_22324_3630# 0.97707f
C9 VDD Cap2 1.32638f
C10 a_12552_1516# a_12264_1516# 2.31595f
C11 B04_OTA_bias_ratio_04_0.Vbias2 a_22934_n4544# 0.78954f
C12 B04_OTA_4.Vbias2 a_33892_1928# 0.62201f
C13 a_11654_3630# a_13014_3630# 1.58973f
C14 VDD VbiasN 4.09468f
C15 B04_OTA_bias_ratio_025_1.Vbias2 a_12552_n4544# 0.61589f
C16 B04_OTA_4.Vin- Cap0 1.34616f
C17 VDD B04_OTA_4.Vbias1 1.49815f
C18 B04_OTA_bias_ratio_025_0.Vbias2 a_984_3630# 0.97418f
C19 B04_OTA_bias_ratio_04_0.Vbias3 a_27346_n2762# 0.72611f
C20 a_11366_n2762# VDD05 0.95626f
C21 B04_OTA_bias_ratio_025_1.Vbias1 a_13014_3630# 1.05715f
C22 B04_OTA_bias_ratio_025_0.Vbias3 B04_OTA_6.Vin- 1.35058f
C23 B04_OTA_bias_ratio_025_1.Vbias2 a_12552_n4132# 0.62263f
C24 a_44374_n2430# a_44374_n2762# 1.56314f
C25 B04_OTA_bias_ratio_025_1.Vbias3 a_15714_n1694# 1.00002f
C26 B04_OTA_bias_ratio_04_0.Vbias2 B04_OTA_3.Vin- 0.70712f
C27 B04_OTA_bias_ratio_04_0.Vbias0 a_27450_n10140# 0.5954f
C28 B04_OTA_bias_ratio_025_1.Vbias1 a_11654_3630# 1.3434f
C29 a_12552_1516# a_13014_3630# 1.15344f
C30 a_23222_n4544# a_22934_n4544# 2.31595f
C31 a_44374_n2430# a_45734_n2430# 1.59101f
C32 VDD B04_OTA_4.Vbias3 15.5149f
C33 B04_OTA_7.Vin+ a_20752_6250# 19.1034f
C34 a_26384_4366# B04_OTA_bias_ratio_04_0.Vbias3 0.88772f
C35 VDD a_38016_3298# 0.96808f
C36 B04_OTA_7.Vin+ a_19752_6250# 11.0536f
C37 B04_OTA_bias_ratio_025_1.Vbias2 a_11654_n2762# 0.52975f
C38 a_32994_n2430# a_34354_n2430# 1.58992f
C39 B04_OTA_bias_ratio_025_0.Vbias3 B04_OTA_7.Vin+ 1.368f
C40 a_26384_4366# a_27346_3298# 1.01293f
C41 B04_OTA_bias_ratio_025_1.Vbias3 VbiasN 0.7445f
C42 a_984_3630# a_984_3298# 1.56313f
C43 a_38120_n10140# VDD 1.55734f
C44 VDD05 Cap2 0.81229f
C45 VDD a_36966_3298# 2.45528f
C46 B04_OTA_bias_ratio_025_1.Vbias2 a_13014_n2430# 0.69769f
C47 a_26384_4366# a_26296_3298# 1.18875f
C48 B04_OTA_bias_ratio_04_0.Vbias2 B04_OTA_bias_ratio_04_0.Vbias0 1.50182f
C49 B04_OTA_8.Vin- a_44374_n2762# 0.56861f
C50 a_984_3630# a_2344_3630# 1.58982f
C51 B04_OTA_bias_ratio_5_0.Vbias3 Vout 1.35293f
C52 B04_OTA_6.Vin- a_6006_n2762# 0.85233f
C53 VDD B04_OTA_bias_ratio_04_0.Vbias3 15.515f
C54 VDD a_32706_3298# 1.25156f
C55 B04_OTA_bias_ratio_025_1.Vbias2 a_11654_n2430# 0.981f
C56 B04_OTA_6.Vin- a_22324_n2430# 0.60908f
C57 B04_OTA_8.Vin- a_45734_n2430# 1.24443f
C58 a_26384_n1694# a_27346_n2762# 1.01293f
C59 a_49396_n2762# Vout 0.85291f
C60 VDD a_27346_3298# 0.96808f
C61 B04_OTA_7.Vin+ a_11366_3298# 0.93546f
C62 B04_OTA_3.Vin- a_32752_6250# 39.334f
C63 VDD a_13014_n2430# 1.00424f
C64 a_49396_n2762# B04_OTA_bias_ratio_5_0.Vbias3 0.61268f
C65 VDD a_26296_3298# 2.45658f
C66 a_48346_n2762# Vout 0.53509f
C67 a_19752_6250# a_20752_6250# 4.19914f
C68 a_33604_1516# B04_OTA_4.Vbias2 0.79923f
C69 B04_OTA_7.Vin+ a_15714_4366# 0.72473f
C70 B04_OTA_3.Vin- a_31752_6250# 19.1082f
C71 a_48346_n2762# B04_OTA_bias_ratio_5_0.Vbias3 0.54346f
C72 VDD a_26296_n2762# 2.45658f
C73 B04_OTA_6.Vin- B04_OTA_4.Vbias2 0.7724f
C74 VDD a_32706_n2762# 1.25156f
C75 a_32994_3298# B04_OTA_4.Vbias2 0.53084f
C76 B04_OTA_3.Vin- a_30752_6250# 8.24385f
C77 B04_OTA_bias_ratio_025_0.Vbias1 VDD 1.49951f
C78 B04_OTA_bias_ratio_025_1.Vbias2 B04_OTA_6.Vin- 0.94065f
C79 VDD a_16676_n2762# 0.93864f
C80 B04_OTA_bias_ratio_025_1.Vbias2 a_12264_n4544# 0.84451f
C81 B04_OTA_4.Vin- B04_OTA_bias_ratio_04_0.Vbias3 1.73296f
C82 a_45272_n4544# a_45272_n4132# 0.51202f
C83 VDD a_22036_n2762# 1.24f
C84 VDD a_37054_n1694# 5.48208f
C85 B04_OTA_bias_ratio_04_0.Vbias0 Cap2 0.9484f
C86 a_34354_3630# B04_OTA_4.Vbias2 0.61059f
C87 B04_OTA_4.Vbias0 B04_OTA_4.Vbias2 1.51682f
C88 B04_OTA_7.Vin+ a_696_n2762# 1.04753f
C89 a_22036_3298# B04_OTA_7.Vin+ 0.9521f
C90 VDD05 a_32706_3298# 1.01236f
C91 B04_OTA_bias_ratio_025_0.Vbias2 a_1882_n4544# 0.60171f
C92 B04_OTA_bias_ratio_025_1.Vbias2 a_12552_1928# 0.6196f
C93 VDD a_26384_n1694# 5.48208f
C94 a_32994_3630# B04_OTA_4.Vbias2 0.98358f
C95 a_45272_n4544# B04_OTA_bias_ratio_5_0.Vbias2 0.57593f
C96 a_45272_n4132# a_44374_n2762# 1.08849f
C97 B04_OTA_4.Vbias2 a_33604_n4544# 0.80884f
C98 VDD a_48434_n1694# 5.48999f
C99 VDD B04_OTA_6.Vin- 22.0698f
C100 B04_OTA_bias_ratio_5_0.Vbias2 a_44984_n4544# 0.80229f
C101 B04_OTA_7.Vin+ B04_OTA_4.Vbias2 0.88178f
C102 B04_OTA_bias_ratio_025_0.Vbias2 a_1882_n4132# 0.62212f
C103 B04_OTA_bias_ratio_025_1.Vbias2 B04_OTA_bias_ratio_025_1.Vbias0 1.50511f
C104 a_23222_1928# a_23222_1516# 0.51202f
C105 B04_OTA_bias_ratio_025_1.Vbias2 B04_OTA_7.Vin+ 0.78057f
C106 VDD a_2344_n2430# 1.03848f
C107 B04_OTA_bias_ratio_025_0.Vbias3 a_5044_4366# 0.88866f
C108 a_37054_4366# B04_OTA_4.Vbias3 0.88865f
C109 B04_OTA_4.Vbias2 a_32994_n2762# 0.51675f
C110 B04_OTA_3.Vin- B04_OTA_bias_ratio_04_0.Vbias3 1.30193f
C111 a_1594_1516# Vin 0.60322f
C112 B04_OTA_bias_ratio_04_0.Vbias1 a_23684_n2430# 1.2177f
C113 B04_OTA_4.Vbias1 a_34354_n2430# 1.21564f
C114 B04_OTA_bias_ratio_5_0.Vbias2 a_44374_n2762# 0.85136f
C115 B04_OTA_3.Vin- a_32706_3298# 0.96465f
C116 a_34354_3630# VDD 1.05289f
C117 B04_OTA_4.Vbias0 VDD 11.858f
C118 VDD B04_OTA_bias_ratio_5_0.Vbias0 9.45659f
C119 a_11654_n2430# VDD05 0.77755f
C120 B04_OTA_bias_ratio_04_0.Vbias2 a_23222_n4544# 0.58178f
C121 a_33892_n4544# a_33604_n4544# 2.31595f
C122 a_37054_4366# a_38016_3298# 1.01293f
C123 B04_OTA_4.Vin- a_32706_n2762# 0.8347f
C124 B04_OTA_bias_ratio_025_1.Vbias3 a_16676_n2762# 0.72174f
C125 a_45272_n4132# a_44374_n2430# 0.91904f
C126 B04_OTA_3.Vin- a_27346_3298# 0.85233f
C127 a_32706_n2762# VDD05 0.95701f
C128 B04_OTA_bias_ratio_025_0.Vbias3 a_6006_n2762# 0.72559f
C129 B04_OTA_4.Vbias1 a_32994_n2430# 1.34687f
C130 B04_OTA_bias_ratio_04_0.Vbias1 a_22324_n2430# 1.33968f
C131 B04_OTA_bias_ratio_5_0.Vbias2 a_45734_n2430# 0.58819f
C132 B04_OTA_bias_ratio_5_0.Vbias3 VbiasN 4.72647f
C133 B04_OTA_4.Vbias0 VbiasP 0.53703f
C134 VDD B04_OTA_bias_ratio_025_1.Vbias0 11.9213f
C135 a_37054_4366# a_36966_3298# 1.18875f
C136 B04_OTA_7.Vin+ VDD 30.6429f
C137 a_22036_n2762# VDD05 0.90675f
C138 B04_OTA_bias_ratio_025_0.Vbias3 a_4956_n2762# 0.63988f
C139 B04_OTA_bias_ratio_5_0.Vbias2 a_44374_n2430# 0.91593f
C140 B04_OTA_bias_ratio_025_0.Vbias2 B04_OTA_bias_ratio_025_0.Vbias1 1.12944f
C141 B04_OTA_bias_ratio_025_1.Vbias0 VbiasP 0.53273f
C142 VDD a_48320_n8570# 1.55734f
C143 a_33604_1516# VDD05 0.65076f
C144 a_33892_n4132# a_32994_n2762# 1.08849f
C145 a_984_n2762# VDD05 0.63163f
C146 B04_OTA_bias_ratio_025_1.Vbias3 B04_OTA_6.Vin- 2.38221f
C147 B04_OTA_bias_ratio_025_0.Vbias2 a_1594_n4544# 0.84555f
C148 VDD a_45734_n2430# 0.83059f
C149 B04_OTA_6.Vin- B04_OTA_4.Vin- 0.76225f
C150 B04_OTA_7.Vin+ a_22934_1516# 0.73341f
C151 B04_OTA_bias_ratio_04_0.Vbias0 B04_OTA_bias_ratio_04_0.Vbias3 1.5379f
C152 B04_OTA_bias_ratio_025_0.Vbias2 a_1882_1516# 0.62282f
C153 B04_OTA_6.Vin- VDD05 1.32628f
C154 a_2344_n2430# VDD05 0.5096f
C155 a_12264_n4544# VDD05 0.60315f
C156 a_38016_n2762# B04_OTA_4.Vbias3 0.72651f
C157 B04_OTA_bias_ratio_025_0.Vbias2 a_984_n2762# 0.52529f
C158 a_22324_n2430# a_22324_n2762# 1.56314f
C159 B04_OTA_6.Vin- a_22934_n4544# 0.72314f
C160 B04_OTA_bias_ratio_025_0.Vbias3 a_5044_n1694# 1.0492f
C161 B04_OTA_bias_ratio_025_0.Vbias2 a_1882_1928# 0.61893f
C162 B04_OTA_bias_ratio_025_0.Vbias2 B04_OTA_6.Vin- 0.70806f
C163 B04_OTA_4.Vbias0 VDD05 0.64062f
C164 B04_OTA_bias_ratio_04_0.Vbias2 a_23222_n4132# 0.62165f
C165 a_22324_n2430# a_23684_n2430# 1.59001f
C166 a_36966_n2762# B04_OTA_4.Vbias3 0.64213f
C167 B04_OTA_bias_ratio_025_0.Vbias2 a_2344_n2430# 0.69815f
C168 B04_OTA_bias_ratio_025_1.Vbias3 B04_OTA_bias_ratio_025_1.Vbias0 1.538f
C169 a_27450_n10140# B04_OTA_bias_ratio_04_0.Vbias3 0.59702f
C170 B04_OTA_bias_ratio_025_1.Vbias3 B04_OTA_7.Vin+ 1.55338f
C171 a_696_3298# Vin 0.93596f
C172 a_32994_3630# VDD05 0.9647f
C173 a_33604_n4544# VDD05 0.60322f
C174 B04_OTA_bias_ratio_025_1.Vbias0 VDD05 0.50282f
C175 a_32994_3298# B04_OTA_3.Vin- 0.58278f
C176 B04_OTA_bias_ratio_025_0.Vbias2 a_984_n2430# 0.9826f
C177 B04_OTA_7.Vin+ VDD05 9.49216f
C178 B04_OTA_7.Vin+ a_22324_3630# 0.89407f
C179 a_31752_n13750# a_32752_n13750# 0.5006f
C180 B04_OTA_bias_ratio_025_1.Vbias1 a_13014_n2430# 1.21667f
C181 B04_OTA_4.Vin- a_32994_n2762# 0.61699f
C182 B04_OTA_bias_ratio_04_0.Vbias1 VDD 1.49733f
C183 a_16676_3298# B04_OTA_7.Vin+ 0.99193f
C184 B04_OTA_bias_ratio_025_0.Vbias1 a_2344_3630# 1.07368f
C185 B04_OTA_bias_ratio_025_0.Vbias0 B04_OTA_7.Vin+ 0.619f
C186 B04_OTA_bias_ratio_025_0.Vbias3 VDD 15.4981f
C187 a_34354_3630# B04_OTA_3.Vin- 0.5096f
C188 B04_OTA_3.Vin- B04_OTA_4.Vbias0 0.59381f
C189 a_23222_n4132# a_23222_n4544# 0.51202f
C190 B04_OTA_bias_ratio_025_0.Vbias2 B04_OTA_7.Vin+ 0.81627f
C191 B04_OTA_bias_ratio_025_1.Vbias1 a_11654_n2430# 1.33994f
C192 a_1882_1516# a_2344_3630# 1.15275f
C193 a_15626_3298# B04_OTA_7.Vin+ 0.59842f
C194 a_1882_1928# a_984_3298# 1.08849f
C195 VDD B04_OTA_8.Vin- 4.46474f
C196 B04_OTA_bias_ratio_025_0.Vbias3 VbiasP 0.6635f
C197 a_5044_n1694# a_6006_n2762# 1.01293f
C198 B04_OTA_bias_ratio_025_0.Vbias2 a_1594_1516# 0.81479f
C199 B04_OTA_3.Vin- B04_OTA_7.Vin+ 0.75131f
C200 a_696_3298# VDD 1.25156f
C201 VDD a_15626_n2762# 2.39878f
C202 a_23222_1516# a_22934_1516# 2.31595f
C203 a_6006_3298# B04_OTA_7.Vin+ 0.85233f
C204 a_31752_6250# a_32752_6250# 0.58841f
C205 a_12552_1928# a_11654_3298# 1.08849f
C206 a_5044_n1694# a_4956_n2762# 1.18875f
C207 a_5044_4366# VDD 5.48999f
C208 VDD a_11366_3298# 1.2402f
C209 B04_OTA_bias_ratio_04_0.Vbias1 a_23684_3630# 1.06466f
C210 B04_OTA_7.Vin+ a_11654_3298# 0.59305f
C211 VDD a_23684_n2430# 1.03263f
C212 VDD Cap1 1.69833f
C213 VDD a_15714_4366# 5.44228f
C214 VDD a_6006_n2762# 0.96808f
C215 VbiasN B04_OTA_4.Vbias3 0.97887f
C216 B04_OTA_bias_ratio_025_1.Vbias1 a_12264_n4544# 0.54935f
C217 a_23222_1928# a_22324_3298# 1.08849f
C218 a_23222_1516# a_23684_3630# 1.15301f
C219 B04_OTA_bias_ratio_04_0.Vbias1 a_22324_3630# 1.35176f
C220 a_37054_n1694# a_38016_n2762# 1.01293f
C221 a_30752_6250# a_31752_6250# 5.82323f
C222 B04_OTA_7.Vin+ a_13014_3630# 0.68965f
C223 a_12552_1928# a_11654_3630# 0.91904f
C224 B04_OTA_bias_ratio_04_0.Vbias1 a_22934_n4544# 0.54945f
C225 B04_OTA_bias_ratio_5_0.Vbias2 a_45272_n4132# 0.74097f
C226 B04_OTA_bias_ratio_025_0.Vbias3 B04_OTA_bias_ratio_025_0.Vbias0 1.538f
C227 B04_OTA_bias_ratio_5_0.Vbias3 a_48434_n1694# 0.72481f
C228 VDD a_4956_n2762# 2.45701f
C229 B04_OTA_8.Vin- VDD05 19.0184f
C230 a_37054_n1694# a_36966_n2762# 1.18875f
C231 B04_OTA_bias_ratio_025_0.Vbias1 a_984_3630# 1.35219f
C232 VDD a_27346_n2762# 0.96808f
C233 B04_OTA_bias_ratio_025_1.Vbias3 a_15626_n2762# 0.63752f
C234 a_2344_3630# a_1594_1516# 1.93342f
C235 B04_OTA_6.Vin- a_38016_n2762# 0.85233f
C236 a_33892_1928# a_33892_1516# 0.51202f
C237 a_34354_n2430# a_33604_n4544# 1.93365f
C238 a_696_3298# VDD05 0.83558f
C239 VDD a_696_n2762# 1.25156f
C240 a_49396_n2762# a_48434_n1694# 1.01293f
C241 a_22036_3298# VDD 1.25156f
C242 a_23222_1928# a_22324_3630# 0.91904f
C243 a_12552_1516# a_12552_1928# 0.51202f
C244 B04_OTA_bias_ratio_5_0.Vbias3 B04_OTA_bias_ratio_5_0.Vbias0 1.53146f
C245 a_33892_n4544# B04_OTA_4.Vbias2 0.58446f
C246 B04_OTA_bias_ratio_04_0.Vbias3 VbiasN 0.9704f
C247 VDD05 a_22324_n2762# 0.6296f
C248 VDD Vin 2.57433f
C249 a_48346_n2762# a_48434_n1694# 1.18875f
C250 VDD a_5044_n1694# 5.48999f
C251 a_6006_3298# B04_OTA_bias_ratio_025_0.Vbias3 0.60663f
C252 a_11366_3298# VDD05 1.01547f
C253 a_26384_4366# VDD 5.48208f
C254 VDD B04_OTA_4.Vbias2 2.11586f
C255 a_38016_3298# B04_OTA_4.Vbias3 0.60744f
C256 a_12552_n4132# a_12552_n4544# 0.51202f
C257 a_1882_1928# a_984_3630# 0.91904f
C258 a_33892_n4132# B04_OTA_4.Vbias2 0.62199f
C259 B04_OTA_bias_ratio_025_1.Vbias2 VDD 1.96459f
C260 a_16770_n10160# B04_OTA_bias_ratio_025_1.Vbias0 0.5954f
C261 B04_OTA_bias_ratio_025_1.Vbias3 a_15714_4366# 0.83891f
C262 a_15714_n1694# a_16676_n2762# 1.01293f
C263 VDD05 a_23684_n2430# 0.5096f
C264 a_32994_n2430# a_32994_n2762# 1.56314f
C265 a_38120_n10140# B04_OTA_4.Vbias3 0.59702f
C266 B04_OTA_bias_ratio_5_0.Vbias2 VDD 4.54152f
C267 a_32752_n13750# B04_OTA_4.Vin- 39.2148f
C268 a_44086_n2762# B04_OTA_6.Vin- 0.95019f
C269 B04_OTA_4.Vbias2 VbiasP 0.83372f
C270 a_36966_3298# B04_OTA_4.Vbias3 0.54364f
C271 a_22934_n4544# a_23684_n2430# 1.93345f
C272 B04_OTA_bias_ratio_5_0.Vbias3 a_48320_n8570# 0.59702f
C273 B04_OTA_bias_ratio_025_1.Vbias2 VbiasP 0.72f
C274 a_16676_3298# a_15714_4366# 1.01292f
C275 B04_OTA_6.Vin- Cap0 0.79634f
C276 B04_OTA_6.Vin- a_11366_n2762# 0.85678f
C277 B04_OTA_bias_ratio_5_0.Vbias2 VbiasP 1.51928f
C278 a_31752_n13750# B04_OTA_4.Vin- 19.2479f
C279 a_33892_n4132# a_33892_n4544# 0.51202f
C280 B04_OTA_4.Vin- a_27346_n2762# 0.85233f
C281 a_15626_3298# a_15714_4366# 1.18041f
C282 a_6006_3298# a_5044_4366# 1.01293f
C283 B04_OTA_6.Vin- a_15714_n1694# 0.59875f
C284 a_696_n2762# VDD05 0.91522f
C285 a_12552_n4132# a_11654_n2762# 1.08849f
C286 a_22036_3298# VDD05 0.83609f
C287 a_12552_n4544# a_13014_n2430# 1.15096f
C288 VDD VbiasP 19.74f
C289 a_1882_n4132# a_1882_n4544# 0.51202f
C290 B04_OTA_bias_ratio_5_0.Vbias1 a_45734_n2430# 1.0024f
C291 a_12552_n4132# a_11654_n2430# 0.91904f
C292 B04_OTA_bias_ratio_5_0.Vbias1 a_44374_n2430# 1.42014f
C293 a_27346_3298# B04_OTA_bias_ratio_04_0.Vbias3 0.60696f
C294 a_33604_1516# a_33892_1516# 2.31595f
C295 B04_OTA_8.Vin- Vout 8.41582f
C296 VDD a_23684_3630# 1.03266f
C297 B04_OTA_4.Vbias0 Cap2 0.81608f
C298 a_37054_n1694# B04_OTA_4.Vbias3 1.0502f
C299 B04_OTA_bias_ratio_025_1.Vbias3 VDD 15.4931f
C300 VDD B04_OTA_4.Vin- 4.2166f
C301 a_26296_3298# B04_OTA_bias_ratio_04_0.Vbias3 0.5436f
C302 a_6110_n10160# B04_OTA_bias_ratio_025_0.Vbias3 0.59702f
C303 a_34354_3630# B04_OTA_4.Vbias1 1.07302f
C304 VDD VDD05 26.4132f
C305 a_16676_3298# VDD 0.93928f
C306 a_23684_3630# a_22934_1516# 1.93338f
C307 B04_OTA_bias_ratio_04_0.Vbias2 B04_OTA_bias_ratio_04_0.Vbias1 1.12736f
C308 B04_OTA_6.Vin- B04_OTA_4.Vbias3 1.46027f
C309 B04_OTA_bias_ratio_025_0.Vbias0 VDD 11.9151f
C310 a_26296_n2762# B04_OTA_bias_ratio_04_0.Vbias3 0.63915f
C311 a_11654_n2430# a_11654_n2762# 1.56314f
C312 B04_OTA_bias_ratio_025_1.Vbias2 a_12264_1516# 0.78752f
C313 a_34354_3630# a_33892_1516# 1.15175f
C314 a_32994_3630# B04_OTA_4.Vbias1 1.34352f
C315 a_12552_n4544# a_12264_n4544# 2.31595f
C316 a_32994_3298# a_33892_1928# 1.08849f
C317 B04_OTA_4.Vbias1 a_33604_n4544# 0.54915f
C318 a_1882_n4544# a_1594_n4544# 2.31595f
C319 B04_OTA_bias_ratio_025_0.Vbias2 VDD 1.99312f
C320 a_15626_3298# VDD 2.40982f
C321 B04_OTA_bias_ratio_04_0.Vbias2 a_23222_1516# 0.65452f
C322 B04_OTA_bias_ratio_025_0.Vbias0 VbiasP 0.65256f
C323 a_11654_n2430# a_13014_n2430# 1.59021f
C324 B04_OTA_4.Vbias0 B04_OTA_4.Vbias3 1.5379f
C325 B04_OTA_bias_ratio_025_1.Vbias2 a_11654_3298# 0.5409f
C326 B04_OTA_bias_ratio_025_0.Vbias2 VbiasP 0.84084f
C327 B04_OTA_3.Vin- VDD 4.90769f
C328 a_22324_3298# VDD05 0.73778f
C329 a_44086_n2762# B04_OTA_8.Vin- 0.82626f
C330 a_22324_3630# a_22324_3298# 1.56314f
C331 B04_OTA_bias_ratio_04_0.Vbias2 a_23222_1928# 0.61945f
C332 a_26384_n1694# B04_OTA_bias_ratio_04_0.Vbias3 1.04904f
C333 a_6006_3298# VDD 0.96808f
C334 B04_OTA_bias_ratio_025_1.Vbias2 a_13014_3630# 0.60988f
C335 a_32994_3630# a_33892_1928# 0.91904f
C336 a_1882_n4544# a_2344_n2430# 1.15663f
C337 a_1882_n4132# a_984_n2762# 1.08849f
C338 B04_OTA_7.Vin+ B04_OTA_4.Vbias3 1.42334f
C339 a_30752_n13750# a_31752_n13750# 5.79039f
C340 B04_OTA_bias_ratio_04_0.Vbias2 a_22324_n2762# 0.51227f
C341 B04_OTA_bias_ratio_025_0.Vbias3 a_4956_3298# 0.54357f
C342 B04_OTA_4.Vbias0 a_38120_n10140# 0.5954f
C343 a_23684_3630# VDD05 0.74552f
C344 a_22324_3630# a_23684_3630# 1.58954f
C345 B04_OTA_7.Vin+ a_21752_6250# 37.0562f
C346 B04_OTA_6.Vin- a_11654_n2762# 0.61959f
C347 B04_OTA_4.Vin- VDD05 0.51267f
C348 B04_OTA_bias_ratio_025_1.Vbias2 a_11654_3630# 0.97648f
C349 B04_OTA_7.Vin+ a_38016_3298# 0.85233f
C350 a_16676_3298# B04_OTA_bias_ratio_025_1.Vbias3 0.60236f
C351 B04_OTA_bias_ratio_04_0.Vbias2 a_23684_n2430# 0.69696f
C352 B04_OTA_4.Vbias2 a_34354_n2430# 0.69715f
C353 a_37054_4366# VDD 5.48208f
C354 B04_OTA_bias_ratio_025_1.Vbias2 B04_OTA_bias_ratio_025_1.Vbias1 1.12844f
C355 B04_OTA_6.Vin- a_13014_n2430# 0.83694f
C356 B04_OTA_bias_ratio_025_0.Vbias0 VDD05 0.5447f
C357 B04_OTA_bias_ratio_025_0.Vbias1 a_1594_n4544# 0.54698f
C358 a_1882_n4132# a_984_n2430# 0.91904f
C359 a_15626_3298# B04_OTA_bias_ratio_025_1.Vbias3 0.54253f
C360 a_13014_3630# VDD 1.01024f
C361 a_15714_n1694# a_15626_n2762# 1.17993f
C362 a_2344_3630# VDD 1.03851f
C363 a_12264_n4544# a_13014_n2430# 1.93344f
C364 B04_OTA_bias_ratio_04_0.Vbias0 VDD 11.9076f
C365 B04_OTA_bias_ratio_04_0.Vbias2 a_22324_n2430# 0.97791f
C366 B04_OTA_4.Vbias2 a_32994_n2430# 0.98152f
C367 a_26384_n1694# a_26296_n2762# 1.18875f
C368 B04_OTA_bias_ratio_025_1.Vbias2 a_12552_1516# 0.664f
C369 a_5044_4366# a_4956_3298# 1.18875f
C370 Cap0 Cap1 5.45817f
C371 B04_OTA_bias_ratio_025_0.Vbias3 VbiasN 0.80026f
C372 B04_OTA_bias_ratio_025_0.Vbias2 B04_OTA_bias_ratio_025_0.Vbias0 1.501f
C373 a_33892_n4544# a_34354_n2430# 1.15295f
C374 B04_OTA_bias_ratio_5_0.Vbias2 Vout 0.70954f
C375 B04_OTA_bias_ratio_04_0.Vbias0 VbiasP 0.53672f
C376 B04_OTA_3.Vin- VDD05 0.96541f
C377 a_23222_n4544# a_23684_n2430# 1.15172f
C378 B04_OTA_6.Vin- a_16676_n2762# 0.9388f
C379 VDD a_34354_n2430# 1.03263f
C380 B04_OTA_bias_ratio_025_1.Vbias1 VDD 1.47238f
C381 B04_OTA_bias_ratio_025_0.Vbias1 a_2344_n2430# 1.21546f
C382 B04_OTA_6.Vin- a_22036_n2762# 0.95745f
C383 a_27450_n10140# VDD 1.55734f
C384 a_12264_1516# VDD05 0.65268f
C385 a_21752_6250# a_20752_6250# 0.77117f
C386 a_1882_1928# a_1882_1516# 0.51202f
C387 a_2344_n2430# a_1594_n4544# 1.93426f
C388 VDD Vout 2.87683f
C389 a_33892_n4132# a_32994_n2430# 0.91904f
C390 B04_OTA_bias_ratio_025_0.Vbias1 a_984_n2430# 1.36223f
C391 a_984_3630# Vin 0.64777f
C392 a_21752_n13750# B04_OTA_6.Vin- 37.0572f
C393 B04_OTA_bias_ratio_5_0.Vbias3 VDD 9.85059f
C394 a_16770_n10160# VDD 1.55734f
C395 a_984_3298# VDD05 0.74888f
C396 a_20752_n13750# a_21752_n13750# 0.68907f
C397 VDD a_38016_n2762# 0.96808f
C398 B04_OTA_bias_ratio_5_0.Vbias1 B04_OTA_bias_ratio_5_0.Vbias2 0.55917f
C399 Cap1 Cap2 5.39843f
C400 a_34354_3630# a_33604_1516# 1.93331f
C401 a_20752_n13750# B04_OTA_6.Vin- 19.1032f
C402 a_49396_n2762# VDD 0.96808f
C403 a_6110_n10160# VDD 1.55734f
C404 a_2344_3630# VDD05 0.81261f
C405 B04_OTA_bias_ratio_025_0.Vbias2 a_984_3298# 0.52652f
C406 a_23222_n4132# a_22324_n2762# 1.08849f
C407 B04_OTA_bias_ratio_04_0.Vbias0 VDD05 0.56574f
C408 a_984_n2430# a_984_n2762# 1.56313f
C409 B04_OTA_7.Vin+ a_1594_n4544# 0.60322f
C410 VDD a_36966_n2762# 2.45196f
C411 a_19752_n13750# B04_OTA_6.Vin- 10.7337f
C412 a_48346_n2762# VDD 2.27494f
C413 a_11654_3630# VDD05 1.00603f
C414 B04_OTA_bias_ratio_04_0.Vbias2 VDD 2.11355f
C415 a_19752_n13750# a_20752_n13750# 4.11775f
C416 B04_OTA_bias_ratio_025_0.Vbias2 a_2344_3630# 0.61257f
C417 B04_OTA_4.Vin- a_34354_n2430# 0.5096f
C418 B04_OTA_bias_ratio_5_0.Vbias1 VDD 1.00479f
C419 B04_OTA_6.Vin- a_44984_n4544# 0.60395f
C420 a_984_n2430# a_2344_n2430# 1.58992f
C421 a_32994_3630# a_32994_3298# 1.56314f
C422 a_1882_1516# a_1594_1516# 2.31595f
C423 a_44086_n2762# VDD 1.25156f
C424 B04_OTA_bias_ratio_04_0.Vbias2 VbiasP 0.83372f
C425 a_23222_n4132# a_22324_n2430# 0.91904f
C426 a_30752_n13750# B04_OTA_4.Vin- 8.54873f
C427 VDD Cap0 1.80898f
C428 B04_OTA_bias_ratio_04_0.Vbias2 a_22934_1516# 0.78241f
C429 VDD a_11366_n2762# 1.23982f
C430 a_16770_n10160# B04_OTA_bias_ratio_025_1.Vbias3 0.59702f
C431 a_32994_n2430# VDD05 0.77755f
C432 a_32994_3630# a_34354_3630# 1.58968f
C433 a_45272_n4544# a_44984_n4544# 2.31595f
C434 a_13014_3630# a_12264_1516# 1.93371f
C435 a_34354_3630# B04_OTA_7.Vin+ 0.51744f
C436 B04_OTA_7.Vin+ a_984_n2430# 0.5462f
C437 B04_OTA_bias_ratio_04_0.Vbias2 a_22324_3298# 0.5333f
C438 a_4956_3298# VDD 2.45408f
C439 VDD a_15714_n1694# 5.43705f
C440 a_48320_n8570# B04_OTA_bias_ratio_5_0.Vbias0 0.5954f
C441 B04_OTA_4.Vbias2 B04_OTA_4.Vbias1 1.12756f
R0 VbiasN VbiasN.t0 25.7454
R1 VbiasN.n1 VbiasN.n0 5.31474
R2 VbiasN.n3 VbiasN.n2 5.05471
R3 VbiasN.n2 VbiasN.n1 5.04905
R4 VbiasN VbiasN.n3 4.31339
R5 VbiasN VbiasN.t2 3.59355
R6 VbiasN VbiasN.t1 3.59355
R7 VbiasN VbiasN.t4 3.12912
R8 VbiasN VbiasN.t3 3.12912
R9 VbiasN.n0 VbiasN 1.213
R10 VbiasN.n1 VbiasN 1.213
R11 VbiasN.n2 VbiasN 0.849974
R12 VbiasN.n3 VbiasN 0.849974
R13 VbiasN.n0 VbiasN 0.148
R14 VbiasP VbiasP.t0 13.282
R15 VbiasP.n3 VbiasP.n2 4.57336
R16 VbiasP.n2 VbiasP.n1 4.54771
R17 VbiasP VbiasP.t4 3.81034
R18 VbiasP VbiasP.t3 3.81034
R19 VbiasP VbiasP.n3 3.71237
R20 VbiasP VbiasP.t2 3.14013
R21 VbiasP VbiasP.t1 3.14013
R22 VbiasP.n1 VbiasP.n0 3.09824
R23 VbiasP.n2 VbiasP 0.8255
R24 VbiasP.n3 VbiasP 0.8255
R25 VbiasP.n0 VbiasP 0.549855
R26 VbiasP.n1 VbiasP 0.546952
R27 VbiasP.n0 VbiasP 0.0963064
R28 VDD05.n66 VDD05.n65 15.7639
R29 VDD05.n29 VDD05.n28 14.6117
R30 VDD05.n21 VDD05.n20 14.6117
R31 VDD05.n5 VDD05.n4 14.6117
R32 VDD05.n83 VDD05.n82 14.6117
R33 VDD05.n9 VDD05.t68 8.11862
R34 VDD05.n41 VDD05.t52 8.11862
R35 VDD05.n33 VDD05.t20 8.11862
R36 VDD05.n68 VDD05.t36 8.11862
R37 VDD05.n25 VDD05.t32 7.93895
R38 VDD05.n17 VDD05.t64 7.93895
R39 VDD05.n1 VDD05.t48 7.93895
R40 VDD05.n0 VDD05.t80 7.93895
R41 VDD05.n11 VDD05.t71 7.87742
R42 VDD05.n43 VDD05.t55 7.87742
R43 VDD05.n35 VDD05.t23 7.87742
R44 VDD05.n32 VDD05.t31 7.87742
R45 VDD05.n29 VDD05.t28 7.87742
R46 VDD05.n24 VDD05.t63 7.87742
R47 VDD05.n21 VDD05.t60 7.87742
R48 VDD05.n70 VDD05.t39 7.87742
R49 VDD05.n8 VDD05.t47 7.87742
R50 VDD05.n5 VDD05.t44 7.87742
R51 VDD05.n82 VDD05.t76 7.87742
R52 VDD05.n15 VDD05.t72 7.87729
R53 VDD05.n47 VDD05.t56 7.87729
R54 VDD05.n39 VDD05.t24 7.87729
R55 VDD05.n28 VDD05.t35 7.87729
R56 VDD05.n20 VDD05.t67 7.87729
R57 VDD05.n74 VDD05.t40 7.87729
R58 VDD05.n4 VDD05.t51 7.87729
R59 VDD05.n83 VDD05.t83 7.87729
R60 VDD05.n79 VDD05.t79 7.87382
R61 VDD05.n14 VDD05.t73 7.8695
R62 VDD05.n13 VDD05.t74 7.8695
R63 VDD05.n12 VDD05.t75 7.8695
R64 VDD05.n10 VDD05.t70 7.8695
R65 VDD05.n9 VDD05.t69 7.8695
R66 VDD05.n46 VDD05.t57 7.8695
R67 VDD05.n45 VDD05.t58 7.8695
R68 VDD05.n44 VDD05.t59 7.8695
R69 VDD05.n42 VDD05.t54 7.8695
R70 VDD05.n41 VDD05.t53 7.8695
R71 VDD05.n38 VDD05.t25 7.8695
R72 VDD05.n37 VDD05.t26 7.8695
R73 VDD05.n36 VDD05.t27 7.8695
R74 VDD05.n34 VDD05.t22 7.8695
R75 VDD05.n33 VDD05.t21 7.8695
R76 VDD05.n31 VDD05.t30 7.8695
R77 VDD05.n30 VDD05.t29 7.8695
R78 VDD05.n27 VDD05.t34 7.8695
R79 VDD05.n26 VDD05.t33 7.8695
R80 VDD05.n23 VDD05.t62 7.8695
R81 VDD05.n22 VDD05.t61 7.8695
R82 VDD05.n19 VDD05.t66 7.8695
R83 VDD05.n18 VDD05.t65 7.8695
R84 VDD05.n73 VDD05.t41 7.8695
R85 VDD05.n72 VDD05.t42 7.8695
R86 VDD05.n71 VDD05.t43 7.8695
R87 VDD05.n69 VDD05.t38 7.8695
R88 VDD05.n68 VDD05.t37 7.8695
R89 VDD05.n7 VDD05.t46 7.8695
R90 VDD05.n6 VDD05.t45 7.8695
R91 VDD05.n3 VDD05.t50 7.8695
R92 VDD05.n2 VDD05.t49 7.8695
R93 VDD05.n80 VDD05.t78 7.8695
R94 VDD05.n81 VDD05.t77 7.8695
R95 VDD05.n84 VDD05.t82 7.8695
R96 VDD05.n85 VDD05.t81 7.8695
R97 VDD05.n67 VDD05.n24 4.98505
R98 VDD05.n76 VDD05.n67 4.77296
R99 VDD05.n78 VDD05.n77 4.766
R100 VDD05.n67 VDD05.n66 4.75975
R101 VDD05.n79 VDD05.n78 4.6655
R102 VDD05.n67 VDD05.n32 4.6005
R103 VDD05.n49 VDD05.n48 4.498
R104 VDD05.n78 VDD05.n8 4.48675
R105 VDD05.n77 VDD05.n16 4.15868
R106 VDD05.n16 VDD05.n11 3.30425
R107 VDD05.n48 VDD05.n43 3.30425
R108 VDD05.n40 VDD05.n35 3.30425
R109 VDD05.n75 VDD05.n70 3.30425
R110 VDD05.n49 VDD05.n40 2.887
R111 VDD05.n76 VDD05.n75 2.8005
R112 VDD05.n16 VDD05.n15 2.2505
R113 VDD05.n48 VDD05.n47 2.2505
R114 VDD05.n40 VDD05.n39 2.2505
R115 VDD05.n75 VDD05.n74 2.2505
R116 VDD05.n10 VDD05.n9 0.24962
R117 VDD05.n42 VDD05.n41 0.24962
R118 VDD05.n34 VDD05.n33 0.24962
R119 VDD05.n31 VDD05.n30 0.24962
R120 VDD05.n23 VDD05.n22 0.24962
R121 VDD05.n69 VDD05.n68 0.24962
R122 VDD05.n7 VDD05.n6 0.24962
R123 VDD05.n81 VDD05.n80 0.24962
R124 VDD05.n13 VDD05.n12 0.247398
R125 VDD05.n14 VDD05.n13 0.247398
R126 VDD05.n45 VDD05.n44 0.247398
R127 VDD05.n46 VDD05.n45 0.247398
R128 VDD05.n37 VDD05.n36 0.247398
R129 VDD05.n38 VDD05.n37 0.247398
R130 VDD05.n27 VDD05.n26 0.247398
R131 VDD05.n19 VDD05.n18 0.247398
R132 VDD05.n72 VDD05.n71 0.247398
R133 VDD05.n73 VDD05.n72 0.247398
R134 VDD05.n3 VDD05.n2 0.247398
R135 VDD05.n85 VDD05.n84 0.247398
R136 VDD05.n80 VDD05.n79 0.2453
R137 VDD05.n11 VDD05.n10 0.2417
R138 VDD05.n43 VDD05.n42 0.2417
R139 VDD05.n35 VDD05.n34 0.2417
R140 VDD05.n30 VDD05.n29 0.2417
R141 VDD05.n32 VDD05.n31 0.2417
R142 VDD05.n22 VDD05.n21 0.2417
R143 VDD05.n24 VDD05.n23 0.2417
R144 VDD05.n70 VDD05.n69 0.2417
R145 VDD05.n6 VDD05.n5 0.2417
R146 VDD05.n8 VDD05.n7 0.2417
R147 VDD05.n82 VDD05.n81 0.2417
R148 VDD05.n15 VDD05.n14 0.239602
R149 VDD05.n47 VDD05.n46 0.239602
R150 VDD05.n39 VDD05.n38 0.239602
R151 VDD05.n28 VDD05.n27 0.239602
R152 VDD05.n20 VDD05.n19 0.239602
R153 VDD05.n74 VDD05.n73 0.239602
R154 VDD05.n4 VDD05.n3 0.239602
R155 VDD05.n84 VDD05.n83 0.239602
R156 VDD05.n56 VDD05.t16 0.163404
R157 VDD05.n58 VDD05.t0 0.163404
R158 VDD05.n55 VDD05.t1 0.163404
R159 VDD05.n54 VDD05.t17 0.163404
R160 VDD05.n53 VDD05.t2 0.163404
R161 VDD05.n52 VDD05.t18 0.163404
R162 VDD05.n51 VDD05.t3 0.163404
R163 VDD05.n50 VDD05.t19 0.163404
R164 VDD05.n26 VDD05 0.159949
R165 VDD05.n18 VDD05 0.159949
R166 VDD05.n2 VDD05 0.159949
R167 VDD05 VDD05.n85 0.159949
R168 VDD05.n57 VDD05.n56 0.126214
R169 VDD05.n59 VDD05.n58 0.121614
R170 VDD05.n64 VDD05.n63 0.1147
R171 VDD05.n62 VDD05.n61 0.1143
R172 VDD05.n61 VDD05.n55 0.106214
R173 VDD05.n61 VDD05.n54 0.106214
R174 VDD05.n63 VDD05.n53 0.106214
R175 VDD05.n63 VDD05.n52 0.106214
R176 VDD05.n65 VDD05.n51 0.106214
R177 VDD05.n65 VDD05.n50 0.106214
R178 VDD05.n60 VDD05.n59 0.1005
R179 VDD05.n77 VDD05.n76 0.0905
R180 VDD05.n12 VDD05 0.0529409
R181 VDD05.n44 VDD05 0.0529409
R182 VDD05.n36 VDD05 0.0529409
R183 VDD05.n71 VDD05 0.0529409
R184 VDD05.n56 VDD05.t12 0.0376901
R185 VDD05.n58 VDD05.t4 0.0376901
R186 VDD05.n57 VDD05.t8 0.0376901
R187 VDD05.n55 VDD05.t5 0.0376901
R188 VDD05.n54 VDD05.t13 0.0376901
R189 VDD05.n60 VDD05.t9 0.0376901
R190 VDD05.n53 VDD05.t6 0.0376901
R191 VDD05.n52 VDD05.t14 0.0376901
R192 VDD05.n62 VDD05.t10 0.0376901
R193 VDD05.n51 VDD05.t7 0.0376901
R194 VDD05.n50 VDD05.t15 0.0376901
R195 VDD05.n64 VDD05.t11 0.0376901
R196 VDD05.n66 VDD05.n49 0.0364331
R197 VDD05 VDD05.n25 0.0185
R198 VDD05 VDD05.n17 0.0185
R199 VDD05 VDD05.n1 0.0185
R200 VDD05 VDD05.n0 0.0185
R201 VDD05.n78 VDD05 0.014
R202 VDD05.n25 VDD05 0.0132559
R203 VDD05.n17 VDD05 0.0132559
R204 VDD05.n1 VDD05 0.0132559
R205 VDD05.n0 VDD05 0.0132559
R206 VDD05.n61 VDD05.n60 0.0067
R207 VDD05.n65 VDD05.n64 0.0067
R208 VDD05.n63 VDD05.n62 0.0063
R209 VDD05.n59 VDD05.n57 0.0051
R210 Vin.n0 Vin.t0 8.11862
R211 Vin.n2 Vin.t3 7.87742
R212 Vin.n4 Vin.t4 7.87729
R213 Vin.n5 Vin.t5 7.8695
R214 Vin.n6 Vin.t6 7.8695
R215 Vin.n7 Vin.t7 7.8695
R216 Vin.n1 Vin.t2 7.8695
R217 Vin.n0 Vin.t1 7.8695
R218 Vin.n3 Vin.n2 3.30425
R219 Vin.n4 Vin.n3 2.2505
R220 Vin.n3 Vin 0.3855
R221 Vin.n1 Vin.n0 0.24962
R222 Vin.n7 Vin.n6 0.247398
R223 Vin.n6 Vin.n5 0.247398
R224 Vin.n2 Vin.n1 0.2417
R225 Vin.n5 Vin.n4 0.239602
R226 Vin Vin.n7 0.0529409
R227 Cap2.n0 Cap2.t2 29.1173
R228 Cap2.n1 Cap2.t3 29.1173
R229 Cap2.n0 Cap2.t0 21.6773
R230 Cap2.n1 Cap2.t1 21.6773
R231 Cap2 Cap2.n0 10.1396
R232 Cap2 Cap2.n1 5.04894
R233 Cap1.n0 Cap1.t2 28.7172
R234 Cap1.n1 Cap1.t3 28.7172
R235 Cap1.n0 Cap1.t0 22.0772
R236 Cap1.n1 Cap1.t1 22.0772
R237 Cap1 Cap1.n0 9.90894
R238 Cap1 Cap1.n1 5.27956
R239 Cap0.n0 Cap0.t2 28.3272
R240 Cap0.n1 Cap0.t3 28.3272
R241 Cap0.n0 Cap0.t0 22.4672
R242 Cap0.n1 Cap0.t1 22.4672
R243 Cap0 Cap0.n0 9.92019
R244 Cap0 Cap0.n1 5.26831
R245 Vout.n2 Vout.t0 569.717
R246 Vout.n0 Vout.t4 15.2778
R247 Vout Vout.t5 14.3449
R248 Vout.n5 Vout.t7 8.85175
R249 Vout.n2 Vout.t1 8.84947
R250 Vout.n3 Vout.t8 6.13782
R251 Vout.n1 Vout.t3 2.89478
R252 Vout.n0 Vout.t2 2.89471
R253 Vout.n6 Vout.t6 2.64079
R254 Vout.t6 Vout.n4 2.61681
R255 Vout.n8 Vout.n7 2.25671
R256 Vout.n3 Vout.n2 2.25397
R257 Vout.n1 Vout.n0 2.08891
R258 Vout.n9 Vout 1.60453
R259 Vout Vout.n8 1.52397
R260 Vout.n9 Vout.n1 0.4655
R261 Vout Vout.n9 0.3455
R262 Vout.n6 Vout.n5 0.303295
R263 Vout.n8 Vout.n3 0.247224
R264 Vout.n7 Vout.n6 0.0696667
R265 Vout.n5 Vout.n4 0.0176429
R266 Vout.n7 Vout.n4 0.00716667
R267 VDD.n124 VDD.t160 440.598
R268 VDD.n121 VDD.t158 440.598
R269 VDD.t259 VDD.t50 430.329
R270 VDD.t50 VDD.t54 430.329
R271 VDD.t54 VDD.t52 430.329
R272 VDD.t52 VDD.t48 430.329
R273 VDD.t239 VDD.t133 430.329
R274 VDD.t133 VDD.t132 430.329
R275 VDD.t132 VDD.t131 430.329
R276 VDD.t131 VDD.t130 430.329
R277 VDD.t219 VDD.t128 430.329
R278 VDD.t128 VDD.t122 430.329
R279 VDD.t122 VDD.t126 430.329
R280 VDD.t126 VDD.t124 430.329
R281 VDD.t199 VDD.t18 430.329
R282 VDD.t18 VDD.t22 430.329
R283 VDD.t22 VDD.t20 430.329
R284 VDD.t20 VDD.t16 430.329
R285 VDD.t146 VDD.t299 430.329
R286 VDD.t145 VDD.t146 430.329
R287 VDD.t144 VDD.t145 430.329
R288 VDD.t143 VDD.t144 430.329
R289 VDD.t137 VDD.t319 430.329
R290 VDD.t136 VDD.t137 430.329
R291 VDD.t135 VDD.t136 430.329
R292 VDD.t134 VDD.t135 430.329
R293 VDD.t14 VDD.t339 430.329
R294 VDD.t12 VDD.t14 430.329
R295 VDD.t8 VDD.t12 430.329
R296 VDD.t10 VDD.t8 430.329
R297 VDD.t150 VDD.t279 430.329
R298 VDD.t154 VDD.t150 430.329
R299 VDD.t152 VDD.t154 430.329
R300 VDD.t148 VDD.t152 430.329
R301 VDD.t189 VDD.t359 430.329
R302 VDD.t188 VDD.t189 430.329
R303 VDD.t187 VDD.t188 430.329
R304 VDD.t186 VDD.t187 430.329
R305 VDD.n236 VDD.n209 397.507
R306 VDD.n265 VDD.n198 397.507
R307 VDD.n290 VDD.n191 397.507
R308 VDD.n316 VDD.n180 397.507
R309 VDD.n327 VDD.n91 397.507
R310 VDD.n333 VDD.n61 397.507
R311 VDD.n339 VDD.n31 397.507
R312 VDD.n345 VDD.n4 397.507
R313 VDD.n374 VDD.n354 397.507
R314 VDD.n239 VDD.n209 388.978
R315 VDD.n265 VDD.n199 388.978
R316 VDD.n293 VDD.n191 388.978
R317 VDD.n316 VDD.n181 388.978
R318 VDD.n327 VDD.n92 388.978
R319 VDD.n333 VDD.n62 388.978
R320 VDD.n339 VDD.n32 388.978
R321 VDD.n345 VDD.n5 388.978
R322 VDD.n374 VDD.n355 388.978
R323 VDD.n148 VDD.t162 359.486
R324 VDD.n158 VDD.t156 359.486
R325 VDD.n239 VDD.n210 354.182
R326 VDD.n268 VDD.n199 354.182
R327 VDD.n293 VDD.n192 354.182
R328 VDD.n319 VDD.n181 354.182
R329 VDD.n324 VDD.n92 354.182
R330 VDD.n330 VDD.n62 354.182
R331 VDD.n336 VDD.n32 354.182
R332 VDD.n342 VDD.n5 354.182
R333 VDD.n377 VDD.n355 354.182
R334 VDD.n236 VDD.n210 346.622
R335 VDD.n268 VDD.n198 346.622
R336 VDD.n290 VDD.n192 346.622
R337 VDD.n319 VDD.n180 346.622
R338 VDD.n324 VDD.n91 346.622
R339 VDD.n330 VDD.n61 346.622
R340 VDD.n336 VDD.n31 346.622
R341 VDD.n342 VDD.n4 346.622
R342 VDD.n377 VDD.n354 346.622
R343 VDD.t256 VDD.t265 323.772
R344 VDD.t236 VDD.t245 323.772
R345 VDD.t216 VDD.t225 323.772
R346 VDD.t196 VDD.t205 323.772
R347 VDD.t296 VDD.t305 323.772
R348 VDD.t325 VDD.t316 323.772
R349 VDD.t336 VDD.t345 323.772
R350 VDD.t285 VDD.t276 323.772
R351 VDD.t365 VDD.t356 323.772
R352 VDD.n345 VDD.t259 258.87
R353 VDD.n339 VDD.t239 258.87
R354 VDD.n333 VDD.t219 258.87
R355 VDD.n327 VDD.t199 258.87
R356 VDD.t299 VDD.n191 258.87
R357 VDD.t319 VDD.n265 258.87
R358 VDD.t339 VDD.n209 258.87
R359 VDD.t279 VDD.n316 258.87
R360 VDD.t359 VDD.n374 258.87
R361 VDD.t48 VDD.n344 220.903
R362 VDD.t130 VDD.n338 220.903
R363 VDD.t124 VDD.n332 220.903
R364 VDD.t16 VDD.n326 220.903
R365 VDD.n292 VDD.t143 220.903
R366 VDD.n266 VDD.t134 220.903
R367 VDD.n238 VDD.t10 220.903
R368 VDD.n317 VDD.t148 220.903
R369 VDD.n375 VDD.t186 220.903
R370 VDD.n134 VDD.t190 209.439
R371 VDD.n161 VDD.t147 208.681
R372 VDD.n141 VDD.t88 208.681
R373 VDD.n136 VDD.t112 208.68
R374 VDD.n147 VDD.t113 208.68
R375 VDD.n157 VDD.t99 208.68
R376 VDD.n167 VDD.t100 208.68
R377 VDD.n170 VDD.t389 208.68
R378 VDD.n176 VDD.t101 208.68
R379 VDD.n151 VDD.t138 208.673
R380 VDD.n172 VDD.t174 184.632
R381 VDD.n163 VDD.t383 184.632
R382 VDD.n153 VDD.t97 184.632
R383 VDD.n143 VDD.t102 184.632
R384 VDD.n132 VDD.t180 184.632
R385 VDD.t4 VDD.t262 184.427
R386 VDD.t32 VDD.t242 184.427
R387 VDD.t28 VDD.t222 184.427
R388 VDD.t56 VDD.t202 184.427
R389 VDD.t64 VDD.t302 184.427
R390 VDD.t322 VDD.t76 184.427
R391 VDD.t80 VDD.t342 184.427
R392 VDD.t282 VDD.t40 184.427
R393 VDD.t362 VDD.t118 184.427
R394 VDD.t265 VDD.t3 183.607
R395 VDD.t0 VDD.t7 183.607
R396 VDD.t245 VDD.t39 183.607
R397 VDD.t36 VDD.t35 183.607
R398 VDD.t225 VDD.t27 183.607
R399 VDD.t24 VDD.t31 183.607
R400 VDD.t205 VDD.t63 183.607
R401 VDD.t60 VDD.t59 183.607
R402 VDD.t305 VDD.t71 183.607
R403 VDD.t68 VDD.t67 183.607
R404 VDD.t75 VDD.t325 183.607
R405 VDD.t79 VDD.t72 183.607
R406 VDD.t345 VDD.t87 183.607
R407 VDD.t84 VDD.t83 183.607
R408 VDD.t47 VDD.t285 183.607
R409 VDD.t43 VDD.t44 183.607
R410 VDD.t117 VDD.t365 183.607
R411 VDD.t121 VDD.t114 183.607
R412 VDD.n343 VDD.t256 160.246
R413 VDD.n337 VDD.t236 160.246
R414 VDD.n331 VDD.t216 160.246
R415 VDD.n325 VDD.t196 160.246
R416 VDD.n291 VDD.t296 160.246
R417 VDD.t316 VDD.n267 160.246
R418 VDD.n237 VDD.t336 160.246
R419 VDD.t276 VDD.n318 160.246
R420 VDD.t356 VDD.n376 160.246
R421 VDD.t262 VDD.n342 139.197
R422 VDD.t242 VDD.n336 139.197
R423 VDD.t222 VDD.n330 139.197
R424 VDD.t202 VDD.n324 139.197
R425 VDD.t302 VDD.n192 139.197
R426 VDD.n268 VDD.t322 139.197
R427 VDD.t342 VDD.n210 139.197
R428 VDD.n319 VDD.t282 139.197
R429 VDD.n377 VDD.t362 139.197
R430 VDD.t3 VDD.t2 124.591
R431 VDD.t2 VDD.t1 124.591
R432 VDD.t6 VDD.t5 124.591
R433 VDD.t5 VDD.t4 124.591
R434 VDD.t39 VDD.t38 124.591
R435 VDD.t38 VDD.t37 124.591
R436 VDD.t34 VDD.t33 124.591
R437 VDD.t33 VDD.t32 124.591
R438 VDD.t27 VDD.t26 124.591
R439 VDD.t26 VDD.t25 124.591
R440 VDD.t30 VDD.t29 124.591
R441 VDD.t29 VDD.t28 124.591
R442 VDD.t63 VDD.t62 124.591
R443 VDD.t62 VDD.t61 124.591
R444 VDD.t58 VDD.t57 124.591
R445 VDD.t57 VDD.t56 124.591
R446 VDD.t71 VDD.t70 124.591
R447 VDD.t70 VDD.t69 124.591
R448 VDD.t66 VDD.t65 124.591
R449 VDD.t65 VDD.t64 124.591
R450 VDD.t74 VDD.t75 124.591
R451 VDD.t73 VDD.t74 124.591
R452 VDD.t77 VDD.t78 124.591
R453 VDD.t76 VDD.t77 124.591
R454 VDD.t87 VDD.t86 124.591
R455 VDD.t86 VDD.t85 124.591
R456 VDD.t82 VDD.t81 124.591
R457 VDD.t81 VDD.t80 124.591
R458 VDD.t46 VDD.t47 124.591
R459 VDD.t45 VDD.t46 124.591
R460 VDD.t41 VDD.t42 124.591
R461 VDD.t40 VDD.t41 124.591
R462 VDD.t116 VDD.t117 124.591
R463 VDD.t115 VDD.t116 124.591
R464 VDD.t119 VDD.t120 124.591
R465 VDD.t118 VDD.t119 124.591
R466 VDD.t106 VDD.t0 95.9021
R467 VDD.t93 VDD.t36 95.9021
R468 VDD.t381 VDD.t24 95.9021
R469 VDD.t168 VDD.t60 95.9021
R470 VDD.t387 VDD.t68 95.9021
R471 VDD.t72 VDD.t95 95.9021
R472 VDD.t110 VDD.t84 95.9021
R473 VDD.t44 VDD.t172 95.9021
R474 VDD.t114 VDD.t178 95.9021
R475 VDD.t7 VDD.t104 90.9841
R476 VDD.t35 VDD.t91 90.9841
R477 VDD.t31 VDD.t379 90.9841
R478 VDD.t59 VDD.t166 90.9841
R479 VDD.t67 VDD.t385 90.9841
R480 VDD.t89 VDD.t79 90.9841
R481 VDD.t83 VDD.t108 90.9841
R482 VDD.t170 VDD.t43 90.9841
R483 VDD.t176 VDD.t121 90.9841
R484 VDD.n138 VDD.t164 52.4332
R485 VDD.n344 VDD.n343 49.1808
R486 VDD.n338 VDD.n337 49.1808
R487 VDD.n332 VDD.n331 49.1808
R488 VDD.n326 VDD.n325 49.1808
R489 VDD.n292 VDD.n291 49.1808
R490 VDD.n267 VDD.n266 49.1808
R491 VDD.n238 VDD.n237 49.1808
R492 VDD.n318 VDD.n317 49.1808
R493 VDD.n376 VDD.n375 49.1808
R494 VDD.n173 VDD.n172 47.281
R495 VDD.n164 VDD.n163 47.281
R496 VDD.n154 VDD.n153 47.281
R497 VDD.n144 VDD.n143 47.281
R498 VDD.n133 VDD.n132 47.281
R499 VDD.n132 VDD.n130 47.281
R500 VDD.n143 VDD.n129 47.281
R501 VDD.n153 VDD.n127 47.281
R502 VDD.n163 VDD.n125 47.281
R503 VDD.n172 VDD.n122 47.281
R504 VDD.t104 VDD.t6 33.6071
R505 VDD.t91 VDD.t34 33.6071
R506 VDD.t379 VDD.t30 33.6071
R507 VDD.t166 VDD.t58 33.6071
R508 VDD.t385 VDD.t66 33.6071
R509 VDD.t78 VDD.t89 33.6071
R510 VDD.t108 VDD.t82 33.6071
R511 VDD.t42 VDD.t170 33.6071
R512 VDD.t120 VDD.t176 33.6071
R513 VDD.t1 VDD.t106 28.689
R514 VDD.t37 VDD.t93 28.689
R515 VDD.t25 VDD.t381 28.689
R516 VDD.t61 VDD.t168 28.689
R517 VDD.t69 VDD.t387 28.689
R518 VDD.t95 VDD.t73 28.689
R519 VDD.t85 VDD.t110 28.689
R520 VDD.t172 VDD.t45 28.689
R521 VDD.t178 VDD.t115 28.689
R522 VDD.n138 VDD.n137 9.36311
R523 VDD.n131 VDD.t390 8.14522
R524 VDD.n142 VDD.t391 8.14522
R525 VDD.n152 VDD.t392 8.14522
R526 VDD.n162 VDD.t393 8.14522
R527 VDD.n171 VDD.t394 8.14522
R528 VDD.n22 VDD.t264 7.90225
R529 VDD.n52 VDD.t244 7.90225
R530 VDD.n82 VDD.t224 7.90225
R531 VDD.n111 VDD.t204 7.90225
R532 VDD.n186 VDD.t304 7.90225
R533 VDD.n254 VDD.t324 7.90225
R534 VDD.n204 VDD.t344 7.90225
R535 VDD.n301 VDD.t284 7.90225
R536 VDD.n364 VDD.t364 7.90225
R537 VDD.n26 VDD.t261 7.9013
R538 VDD.n56 VDD.t241 7.9013
R539 VDD.n86 VDD.t221 7.9013
R540 VDD.n115 VDD.t201 7.9013
R541 VDD.n183 VDD.t301 7.9013
R542 VDD.n250 VDD.t321 7.9013
R543 VDD.n201 VDD.t341 7.9013
R544 VDD.n304 VDD.t281 7.9013
R545 VDD.n348 VDD.t361 7.9013
R546 VDD.n24 VDD.t269 7.8695
R547 VDD.n28 VDD.t267 7.8695
R548 VDD.n54 VDD.t249 7.8695
R549 VDD.n58 VDD.t247 7.8695
R550 VDD.n84 VDD.t229 7.8695
R551 VDD.n88 VDD.t227 7.8695
R552 VDD.n113 VDD.t209 7.8695
R553 VDD.n117 VDD.t207 7.8695
R554 VDD.n185 VDD.t307 7.8695
R555 VDD.n188 VDD.t309 7.8695
R556 VDD.n252 VDD.t327 7.8695
R557 VDD.n256 VDD.t329 7.8695
R558 VDD.n203 VDD.t347 7.8695
R559 VDD.n206 VDD.t349 7.8695
R560 VDD.n303 VDD.t289 7.8695
R561 VDD.n306 VDD.t287 7.8695
R562 VDD.n366 VDD.t369 7.8695
R563 VDD.n350 VDD.t367 7.8695
R564 VDD.n19 VDD.n18 6.45853
R565 VDD.n49 VDD.n48 6.45853
R566 VDD.n79 VDD.n78 6.45853
R567 VDD.n108 VDD.n107 6.45853
R568 VDD.n240 VDD.n208 6.45853
R569 VDD.n261 VDD.n260 6.45853
R570 VDD.n294 VDD.n190 6.45853
R571 VDD.n312 VDD.n311 6.45853
R572 VDD.n371 VDD.n370 6.45853
R573 VDD.n22 VDD.t266 4.42237
R574 VDD.n23 VDD.t270 4.42237
R575 VDD.n52 VDD.t246 4.42237
R576 VDD.n53 VDD.t250 4.42237
R577 VDD.n82 VDD.t226 4.42237
R578 VDD.n83 VDD.t230 4.42237
R579 VDD.n111 VDD.t206 4.42237
R580 VDD.n112 VDD.t210 4.42237
R581 VDD.n186 VDD.t306 4.42237
R582 VDD.n187 VDD.t310 4.42237
R583 VDD.n254 VDD.t326 4.42237
R584 VDD.n255 VDD.t330 4.42237
R585 VDD.n204 VDD.t346 4.42237
R586 VDD.n205 VDD.t350 4.42237
R587 VDD.n301 VDD.t286 4.42237
R588 VDD.n302 VDD.t290 4.42237
R589 VDD.n364 VDD.t366 4.42237
R590 VDD.n365 VDD.t370 4.42237
R591 VDD.n26 VDD.t263 4.42191
R592 VDD.n27 VDD.t268 4.42191
R593 VDD.n56 VDD.t243 4.42191
R594 VDD.n57 VDD.t248 4.42191
R595 VDD.n86 VDD.t223 4.42191
R596 VDD.n87 VDD.t228 4.42191
R597 VDD.n115 VDD.t203 4.42191
R598 VDD.n116 VDD.t208 4.42191
R599 VDD.n183 VDD.t303 4.42191
R600 VDD.n184 VDD.t308 4.42191
R601 VDD.n250 VDD.t323 4.42191
R602 VDD.n251 VDD.t328 4.42191
R603 VDD.n201 VDD.t343 4.42191
R604 VDD.n202 VDD.t348 4.42191
R605 VDD.n304 VDD.t283 4.42191
R606 VDD.n305 VDD.t288 4.42191
R607 VDD.n348 VDD.t363 4.42191
R608 VDD.n349 VDD.t368 4.42191
R609 VDD.n29 VDD.n25 4.3205
R610 VDD.n59 VDD.n55 4.3205
R611 VDD.n89 VDD.n85 4.3205
R612 VDD.n118 VDD.n114 4.3205
R613 VDD.n298 VDD.n297 4.3205
R614 VDD.n257 VDD.n253 4.3205
R615 VDD.n244 VDD.n243 4.3205
R616 VDD.n308 VDD.n307 4.3205
R617 VDD.n367 VDD.n351 4.3205
R618 VDD.n170 VDD.n169 4.2433
R619 VDD.n139 VDD.n138 4.22332
R620 VDD.n123 VDD.t161 4.0565
R621 VDD.n120 VDD.t159 4.0565
R622 VDD.n141 VDD.n140 3.87445
R623 VDD.n213 VDD.t338 3.82424
R624 VDD.n234 VDD.t335 3.82424
R625 VDD.n228 VDD.t318 3.82424
R626 VDD.n222 VDD.t315 3.82424
R627 VDD.n195 VDD.t298 3.82424
R628 VDD.n288 VDD.t295 3.82424
R629 VDD.n277 VDD.t275 3.82424
R630 VDD.n282 VDD.t278 3.82424
R631 VDD.n93 VDD.t195 3.82424
R632 VDD.n97 VDD.t198 3.82424
R633 VDD.n63 VDD.t215 3.82424
R634 VDD.n67 VDD.t218 3.82424
R635 VDD.n33 VDD.t235 3.82424
R636 VDD.n37 VDD.t238 3.82424
R637 VDD.n6 VDD.t255 3.82424
R638 VDD.n2 VDD.t258 3.82424
R639 VDD.n352 VDD.t355 3.82424
R640 VDD.n360 VDD.t358 3.82424
R641 VDD.n16 VDD.t271 3.79275
R642 VDD.n17 VDD.t273 3.79275
R643 VDD.n45 VDD.t251 3.79275
R644 VDD.n46 VDD.t253 3.79275
R645 VDD.n75 VDD.t231 3.79275
R646 VDD.n76 VDD.t233 3.79275
R647 VDD.n104 VDD.t211 3.79275
R648 VDD.n105 VDD.t213 3.79275
R649 VDD.n300 VDD.t291 3.79275
R650 VDD.n299 VDD.t293 3.79275
R651 VDD.n189 VDD.t311 3.79275
R652 VDD.n247 VDD.t313 3.79275
R653 VDD.n246 VDD.t331 3.79275
R654 VDD.n245 VDD.t333 3.79275
R655 VDD.n207 VDD.t351 3.79275
R656 VDD.n214 VDD.t353 3.79275
R657 VDD.n363 VDD.t371 3.79275
R658 VDD.n362 VDD.t373 3.79275
R659 VDD.n161 VDD.n160 3.6659
R660 VDD.n151 VDD.n150 3.65899
R661 VDD.n133 VDD.n131 3.49093
R662 VDD.n144 VDD.n142 3.49093
R663 VDD.n154 VDD.n152 3.49093
R664 VDD.n164 VDD.n162 3.49093
R665 VDD.n173 VDD.n171 3.49093
R666 VDD.n149 VDD.n148 3.28536
R667 VDD.n159 VDD.n158 3.28536
R668 VDD.n168 VDD.n124 3.04894
R669 VDD.n177 VDD.n121 3.04894
R670 VDD.n179 VDD.n178 3.01202
R671 VDD.n150 VDD.n128 2.69757
R672 VDD.n160 VDD.n126 2.69757
R673 VDD.n169 VDD.n123 2.69414
R674 VDD.n178 VDD.n120 2.69414
R675 VDD.n148 VDD.n128 2.64558
R676 VDD.n158 VDD.n126 2.64558
R677 VDD.n124 VDD.n123 2.5559
R678 VDD.n121 VDD.n120 2.5559
R679 VDD.n13 VDD.t107 2.23238
R680 VDD.n42 VDD.t94 2.23238
R681 VDD.n72 VDD.t382 2.23238
R682 VDD.n102 VDD.t169 2.23238
R683 VDD.n232 VDD.t111 2.23238
R684 VDD.n224 VDD.t96 2.23238
R685 VDD.n286 VDD.t388 2.23238
R686 VDD.n276 VDD.t173 2.23238
R687 VDD.n381 VDD.t179 2.23238
R688 VDD.n14 VDD.t105 2.23023
R689 VDD.n43 VDD.t92 2.23023
R690 VDD.n73 VDD.t380 2.23023
R691 VDD.n103 VDD.t167 2.23023
R692 VDD.n231 VDD.t109 2.23023
R693 VDD.n196 VDD.t90 2.23023
R694 VDD.n285 VDD.t386 2.23023
R695 VDD.n119 VDD.t171 2.23023
R696 VDD.n379 VDD.t177 2.23023
R697 VDD.n126 VDD.t157 2.2105
R698 VDD.n128 VDD.t163 2.2105
R699 VDD.t274 VDD.n1 1.97684
R700 VDD.t272 VDD.n20 1.97684
R701 VDD.t254 VDD.n47 1.97684
R702 VDD.t252 VDD.n50 1.97684
R703 VDD.t234 VDD.n77 1.97684
R704 VDD.t232 VDD.n80 1.97684
R705 VDD.t214 VDD.n106 1.97684
R706 VDD.t212 VDD.n109 1.97684
R707 VDD.t312 VDD.n295 1.97684
R708 VDD.n259 VDD.t332 1.97684
R709 VDD.t352 VDD.n241 1.97684
R710 VDD.n215 VDD.t354 1.97684
R711 VDD.n262 VDD.t334 1.97684
R712 VDD.n248 VDD.t314 1.97684
R713 VDD.n313 VDD.t294 1.97684
R714 VDD.n310 VDD.t292 1.97684
R715 VDD.n372 VDD.t374 1.97684
R716 VDD.n369 VDD.t372 1.97684
R717 VDD.n18 VDD.t274 1.97376
R718 VDD.n21 VDD.t272 1.97376
R719 VDD.n48 VDD.t254 1.97376
R720 VDD.n51 VDD.t252 1.97376
R721 VDD.n78 VDD.t234 1.97376
R722 VDD.n81 VDD.t232 1.97376
R723 VDD.n107 VDD.t214 1.97376
R724 VDD.n110 VDD.t212 1.97376
R725 VDD.n296 VDD.t312 1.97376
R726 VDD.t332 VDD.n258 1.97376
R727 VDD.n242 VDD.t352 1.97376
R728 VDD.t354 VDD.n208 1.97376
R729 VDD.t334 VDD.n261 1.97376
R730 VDD.t314 VDD.n190 1.97376
R731 VDD.t294 VDD.n312 1.97376
R732 VDD.t292 VDD.n309 1.97376
R733 VDD.t374 VDD.n371 1.97376
R734 VDD.t372 VDD.n368 1.97376
R735 VDD.n140 VDD.n137 1.84978
R736 VDD.n211 VDD.t11 1.7685
R737 VDD.n211 VDD.t9 1.7685
R738 VDD.n212 VDD.t13 1.7685
R739 VDD.n212 VDD.t15 1.7685
R740 VDD.n221 VDD.t375 1.7685
R741 VDD.n221 VDD.t376 1.7685
R742 VDD.n220 VDD.t377 1.7685
R743 VDD.n220 VDD.t378 1.7685
R744 VDD.n193 VDD.t182 1.7685
R745 VDD.n193 VDD.t183 1.7685
R746 VDD.n194 VDD.t184 1.7685
R747 VDD.n194 VDD.t185 1.7685
R748 VDD.n275 VDD.t149 1.7685
R749 VDD.n275 VDD.t153 1.7685
R750 VDD.n274 VDD.t155 1.7685
R751 VDD.n274 VDD.t151 1.7685
R752 VDD.n95 VDD.t17 1.7685
R753 VDD.n95 VDD.t21 1.7685
R754 VDD.n96 VDD.t23 1.7685
R755 VDD.n96 VDD.t19 1.7685
R756 VDD.n65 VDD.t125 1.7685
R757 VDD.n65 VDD.t127 1.7685
R758 VDD.n66 VDD.t123 1.7685
R759 VDD.n66 VDD.t129 1.7685
R760 VDD.n35 VDD.t139 1.7685
R761 VDD.n35 VDD.t140 1.7685
R762 VDD.n36 VDD.t141 1.7685
R763 VDD.n36 VDD.t142 1.7685
R764 VDD.n8 VDD.t49 1.7685
R765 VDD.n8 VDD.t53 1.7685
R766 VDD.n9 VDD.t55 1.7685
R767 VDD.n9 VDD.t51 1.7685
R768 VDD.n357 VDD.t192 1.7685
R769 VDD.n357 VDD.t193 1.7685
R770 VDD.n356 VDD.t191 1.7685
R771 VDD.n356 VDD.t194 1.7685
R772 VDD VDD.n136 1.37198
R773 VDD.n216 VDD.n215 1.35607
R774 VDD.n373 VDD.n372 1.35607
R775 VDD.n378 VDD.n351 1.3505
R776 VDD.n137 VDD 1.33215
R777 VDD.n134 VDD.n133 1.22724
R778 VDD.n145 VDD.n144 1.22724
R779 VDD.n155 VDD.n154 1.22724
R780 VDD.n165 VDD.n164 1.22724
R781 VDD.n174 VDD.n173 1.22724
R782 VDD.n217 VDD.n216 1.1968
R783 VDD.n373 VDD.n361 1.1968
R784 VDD.n379 VDD.n378 1.1105
R785 VDD.n135 VDD.n134 0.964235
R786 VDD.n146 VDD.n145 0.964235
R787 VDD.n156 VDD.n155 0.964235
R788 VDD.n166 VDD.n165 0.964235
R789 VDD.n175 VDD.n174 0.964235
R790 VDD.n213 VDD.t340 0.885589
R791 VDD.n234 VDD.t337 0.885589
R792 VDD.n228 VDD.t320 0.885589
R793 VDD.n222 VDD.t317 0.885589
R794 VDD.n195 VDD.t300 0.885589
R795 VDD.n288 VDD.t297 0.885589
R796 VDD.n277 VDD.t277 0.885589
R797 VDD.n282 VDD.t280 0.885589
R798 VDD.n93 VDD.t197 0.885589
R799 VDD.n97 VDD.t200 0.885589
R800 VDD.n63 VDD.t217 0.885589
R801 VDD.n67 VDD.t220 0.885589
R802 VDD.n33 VDD.t237 0.885589
R803 VDD.n37 VDD.t240 0.885589
R804 VDD.n6 VDD.t257 0.885589
R805 VDD.n2 VDD.t260 0.885589
R806 VDD.n352 VDD.t357 0.885589
R807 VDD.n360 VDD.t360 0.885589
R808 VDD.n122 VDD.t175 0.8845
R809 VDD.n125 VDD.t384 0.8845
R810 VDD.n127 VDD.t98 0.8845
R811 VDD.n129 VDD.t103 0.8845
R812 VDD.n130 VDD.t181 0.8845
R813 VDD.n322 VDD.n321 0.870949
R814 VDD.n219 VDD.n218 0.822239
R815 VDD.n227 VDD.n226 0.822239
R816 VDD.n273 VDD.n272 0.822239
R817 VDD.n281 VDD.n280 0.822239
R818 VDD.n100 VDD.n99 0.822239
R819 VDD.n70 VDD.n69 0.822239
R820 VDD.n40 VDD.n39 0.822239
R821 VDD.n11 VDD.n10 0.822239
R822 VDD.n359 VDD.n358 0.822239
R823 VDD.n103 VDD.n102 0.763543
R824 VDD.n232 VDD.n231 0.763543
R825 VDD.n224 VDD.n196 0.763543
R826 VDD.n276 VDD.n119 0.763543
R827 VDD.n286 VDD.n285 0.763543
R828 VDD.n73 VDD.n72 0.763543
R829 VDD.n43 VDD.n42 0.763543
R830 VDD.n14 VDD.n13 0.763543
R831 VDD.n155 VDD.n151 0.758655
R832 VDD.n149 VDD.n147 0.757844
R833 VDD.n159 VDD.n157 0.757844
R834 VDD.n168 VDD.n167 0.757844
R835 VDD.n174 VDD.n170 0.757844
R836 VDD.n177 VDD.n176 0.757844
R837 VDD.n145 VDD.n141 0.75583
R838 VDD.n165 VDD.n161 0.75505
R839 VDD.n381 VDD.n380 0.712674
R840 VDD.n140 VDD.n139 0.646164
R841 VDD.n136 VDD.n135 0.620228
R842 VDD.n147 VDD.n146 0.620228
R843 VDD.n157 VDD.n156 0.620228
R844 VDD.n167 VDD.n166 0.620228
R845 VDD.n176 VDD.n175 0.620228
R846 VDD.n323 VDD.n103 0.607155
R847 VDD VDD.n149 0.597845
R848 VDD VDD.n159 0.597845
R849 VDD VDD.n168 0.597845
R850 VDD VDD.n177 0.597845
R851 VDD.n233 VDD.n219 0.446587
R852 VDD.n226 VDD.n225 0.446587
R853 VDD.n287 VDD.n273 0.446587
R854 VDD.n280 VDD.n279 0.446587
R855 VDD.n101 VDD.n100 0.446587
R856 VDD.n71 VDD.n70 0.446587
R857 VDD.n41 VDD.n40 0.446587
R858 VDD.n12 VDD.n11 0.446587
R859 VDD.n358 VDD.n0 0.446587
R860 VDD.n218 VDD.n217 0.442674
R861 VDD.n229 VDD.n227 0.442674
R862 VDD.n272 VDD.n271 0.442674
R863 VDD.n283 VDD.n281 0.442674
R864 VDD.n99 VDD.n98 0.442674
R865 VDD.n69 VDD.n68 0.442674
R866 VDD.n39 VDD.n38 0.442674
R867 VDD.n10 VDD.n3 0.442674
R868 VDD.n361 VDD.n359 0.442674
R869 VDD.n231 VDD.n230 0.356587
R870 VDD.n270 VDD.n196 0.356587
R871 VDD.n321 VDD.n119 0.356587
R872 VDD.n285 VDD.n284 0.356587
R873 VDD.n74 VDD.n73 0.356587
R874 VDD.n44 VDD.n43 0.356587
R875 VDD.n15 VDD.n14 0.356587
R876 VDD.n169 VDD 0.342978
R877 VDD.n178 VDD 0.342978
R878 VDD.n150 VDD 0.340582
R879 VDD.n160 VDD 0.340582
R880 VDD.n25 VDD.n21 0.301027
R881 VDD.n55 VDD.n51 0.301027
R882 VDD.n85 VDD.n81 0.301027
R883 VDD.n114 VDD.n110 0.301027
R884 VDD.n297 VDD.n296 0.301027
R885 VDD.n258 VDD.n257 0.301027
R886 VDD.n243 VDD.n242 0.301027
R887 VDD.n309 VDD.n308 0.301027
R888 VDD.n368 VDD.n367 0.301027
R889 VDD.n380 VDD.n347 0.293561
R890 VDD.n219 VDD.n211 0.270875
R891 VDD.n218 VDD.n212 0.270875
R892 VDD.n226 VDD.n221 0.270875
R893 VDD.n227 VDD.n220 0.270875
R894 VDD.n273 VDD.n193 0.270875
R895 VDD.n272 VDD.n194 0.270875
R896 VDD.n280 VDD.n275 0.270875
R897 VDD.n281 VDD.n274 0.270875
R898 VDD.n100 VDD.n95 0.270875
R899 VDD.n99 VDD.n96 0.270875
R900 VDD.n70 VDD.n65 0.270875
R901 VDD.n69 VDD.n66 0.270875
R902 VDD.n40 VDD.n35 0.270875
R903 VDD.n39 VDD.n36 0.270875
R904 VDD.n11 VDD.n8 0.270875
R905 VDD.n10 VDD.n9 0.270875
R906 VDD.n358 VDD.n357 0.270875
R907 VDD.n359 VDD.n356 0.270875
R908 VDD.n216 VDD.n209 0.263
R909 VDD.n210 VDD.n200 0.263
R910 VDD.n265 VDD.n264 0.263
R911 VDD.n269 VDD.n268 0.263
R912 VDD.n197 VDD.n191 0.263
R913 VDD.n192 VDD.n182 0.263
R914 VDD.n316 VDD.n315 0.263
R915 VDD.n320 VDD.n319 0.263
R916 VDD.n324 VDD.n323 0.263
R917 VDD.n328 VDD.n327 0.263
R918 VDD.n330 VDD.n329 0.263
R919 VDD.n334 VDD.n333 0.263
R920 VDD.n336 VDD.n335 0.263
R921 VDD.n340 VDD.n339 0.263
R922 VDD.n342 VDD.n341 0.263
R923 VDD.n374 VDD.n373 0.263
R924 VDD.n378 VDD.n377 0.263
R925 VDD.n346 VDD.n345 0.263
R926 VDD.n321 VDD.n320 0.251068
R927 VDD.n323 VDD.n322 0.233682
R928 VDD.n320 VDD.n179 0.232227
R929 VDD.n347 VDD.n1 0.22607
R930 VDD.n47 VDD.n30 0.22607
R931 VDD.n77 VDD.n60 0.22607
R932 VDD.n106 VDD.n90 0.22607
R933 VDD.n263 VDD.n262 0.22607
R934 VDD.n249 VDD.n248 0.22607
R935 VDD.n314 VDD.n313 0.22607
R936 VDD.n30 VDD.n29 0.2105
R937 VDD.n60 VDD.n59 0.2105
R938 VDD.n90 VDD.n89 0.2105
R939 VDD.n322 VDD.n118 0.2105
R940 VDD.n314 VDD.n298 0.2105
R941 VDD.n253 VDD.n249 0.2105
R942 VDD.n263 VDD.n244 0.2105
R943 VDD.n307 VDD.n179 0.2105
R944 VDD.n102 VDD 0.196152
R945 VDD VDD.n232 0.196152
R946 VDD VDD.n224 0.196152
R947 VDD VDD.n276 0.196152
R948 VDD VDD.n286 0.196152
R949 VDD.n72 VDD 0.196152
R950 VDD.n42 VDD 0.196152
R951 VDD.n13 VDD 0.196152
R952 VDD VDD.n381 0.196152
R953 VDD.n230 VDD.n200 0.190586
R954 VDD.n270 VDD.n269 0.190586
R955 VDD.n284 VDD.n182 0.190586
R956 VDD.n329 VDD.n74 0.190586
R957 VDD.n335 VDD.n44 0.190586
R958 VDD.n341 VDD.n15 0.190586
R959 VDD.n131 VDD.n130 0.176849
R960 VDD.n142 VDD.n129 0.176849
R961 VDD.n152 VDD.n127 0.176849
R962 VDD.n162 VDD.n125 0.176849
R963 VDD.n171 VDD.n122 0.176849
R964 VDD VDD.n101 0.176587
R965 VDD.n233 VDD 0.176587
R966 VDD.n225 VDD 0.176587
R967 VDD.n279 VDD 0.176587
R968 VDD.n287 VDD 0.176587
R969 VDD VDD.n71 0.176587
R970 VDD VDD.n41 0.176587
R971 VDD VDD.n12 0.176587
R972 VDD VDD.n0 0.176587
R973 VDD.n264 VDD.n263 0.175845
R974 VDD.n249 VDD.n197 0.175845
R975 VDD.n315 VDD.n314 0.175845
R976 VDD.n328 VDD.n90 0.175845
R977 VDD.n334 VDD.n60 0.175845
R978 VDD.n340 VDD.n30 0.175845
R979 VDD.n139 VDD.t165 0.171413
R980 VDD.n135 VDD.n130 0.113886
R981 VDD.n146 VDD.n129 0.113886
R982 VDD.n156 VDD.n127 0.113886
R983 VDD.n166 VDD.n125 0.113886
R984 VDD.n175 VDD.n122 0.113886
R985 VDD.n20 VDD.n19 0.11357
R986 VDD.n50 VDD.n49 0.11357
R987 VDD.n80 VDD.n79 0.11357
R988 VDD.n109 VDD.n108 0.11357
R989 VDD.n295 VDD.n294 0.11357
R990 VDD.n260 VDD.n259 0.11357
R991 VDD.n241 VDD.n240 0.11357
R992 VDD.n311 VDD.n310 0.11357
R993 VDD.n370 VDD.n369 0.11357
R994 VDD.n346 VDD.n3 0.1069
R995 VDD.n23 VDD.n22 0.1001
R996 VDD.n27 VDD.n26 0.1001
R997 VDD.n53 VDD.n52 0.1001
R998 VDD.n57 VDD.n56 0.1001
R999 VDD.n83 VDD.n82 0.1001
R1000 VDD.n87 VDD.n86 0.1001
R1001 VDD.n112 VDD.n111 0.1001
R1002 VDD.n116 VDD.n115 0.1001
R1003 VDD.n184 VDD.n183 0.1001
R1004 VDD.n187 VDD.n186 0.1001
R1005 VDD.n251 VDD.n250 0.1001
R1006 VDD.n255 VDD.n254 0.1001
R1007 VDD.n202 VDD.n201 0.1001
R1008 VDD.n205 VDD.n204 0.1001
R1009 VDD.n302 VDD.n301 0.1001
R1010 VDD.n305 VDD.n304 0.1001
R1011 VDD.n365 VDD.n364 0.1001
R1012 VDD.n349 VDD.n348 0.1001
R1013 VDD.n25 VDD.n24 0.0791
R1014 VDD.n29 VDD.n28 0.0791
R1015 VDD.n55 VDD.n54 0.0791
R1016 VDD.n59 VDD.n58 0.0791
R1017 VDD.n85 VDD.n84 0.0791
R1018 VDD.n89 VDD.n88 0.0791
R1019 VDD.n114 VDD.n113 0.0791
R1020 VDD.n118 VDD.n117 0.0791
R1021 VDD.n298 VDD.n185 0.0791
R1022 VDD.n297 VDD.n188 0.0791
R1023 VDD.n253 VDD.n252 0.0791
R1024 VDD.n257 VDD.n256 0.0791
R1025 VDD.n244 VDD.n203 0.0791
R1026 VDD.n243 VDD.n206 0.0791
R1027 VDD.n308 VDD.n303 0.0791
R1028 VDD.n307 VDD.n306 0.0791
R1029 VDD.n367 VDD.n366 0.0791
R1030 VDD.n351 VDD.n350 0.0791
R1031 VDD.n240 VDD.n239 0.0697308
R1032 VDD.n239 VDD.n238 0.0697308
R1033 VDD.n236 VDD.n235 0.0697308
R1034 VDD.n237 VDD.n236 0.0697308
R1035 VDD.n260 VDD.n199 0.0697308
R1036 VDD.n266 VDD.n199 0.0697308
R1037 VDD.n223 VDD.n198 0.0697308
R1038 VDD.n267 VDD.n198 0.0697308
R1039 VDD.n294 VDD.n293 0.0697308
R1040 VDD.n293 VDD.n292 0.0697308
R1041 VDD.n290 VDD.n289 0.0697308
R1042 VDD.n291 VDD.n290 0.0697308
R1043 VDD.n278 VDD.n180 0.0697308
R1044 VDD.n318 VDD.n180 0.0697308
R1045 VDD.n311 VDD.n181 0.0697308
R1046 VDD.n317 VDD.n181 0.0697308
R1047 VDD.n108 VDD.n92 0.0697308
R1048 VDD.n326 VDD.n92 0.0697308
R1049 VDD.n94 VDD.n91 0.0697308
R1050 VDD.n325 VDD.n91 0.0697308
R1051 VDD.n79 VDD.n62 0.0697308
R1052 VDD.n332 VDD.n62 0.0697308
R1053 VDD.n64 VDD.n61 0.0697308
R1054 VDD.n331 VDD.n61 0.0697308
R1055 VDD.n49 VDD.n32 0.0697308
R1056 VDD.n338 VDD.n32 0.0697308
R1057 VDD.n34 VDD.n31 0.0697308
R1058 VDD.n337 VDD.n31 0.0697308
R1059 VDD.n19 VDD.n5 0.0697308
R1060 VDD.n344 VDD.n5 0.0697308
R1061 VDD.n7 VDD.n4 0.0697308
R1062 VDD.n343 VDD.n4 0.0697308
R1063 VDD.n354 VDD.n353 0.0697308
R1064 VDD.n376 VDD.n354 0.0697308
R1065 VDD.n370 VDD.n355 0.0697308
R1066 VDD.n375 VDD.n355 0.0697308
R1067 VDD.n217 VDD.n213 0.0656477
R1068 VDD.n229 VDD.n228 0.0656477
R1069 VDD.n271 VDD.n195 0.0656477
R1070 VDD.n283 VDD.n282 0.0656477
R1071 VDD.n98 VDD.n97 0.0656477
R1072 VDD.n68 VDD.n67 0.0656477
R1073 VDD.n38 VDD.n37 0.0656477
R1074 VDD.n3 VDD.n2 0.0656477
R1075 VDD.n361 VDD.n360 0.0656477
R1076 VDD.n17 VDD.n1 0.0622419
R1077 VDD.n20 VDD.n16 0.0622419
R1078 VDD.n47 VDD.n46 0.0622419
R1079 VDD.n50 VDD.n45 0.0622419
R1080 VDD.n77 VDD.n76 0.0622419
R1081 VDD.n80 VDD.n75 0.0622419
R1082 VDD.n106 VDD.n105 0.0622419
R1083 VDD.n109 VDD.n104 0.0622419
R1084 VDD.n295 VDD.n189 0.0622419
R1085 VDD.n259 VDD.n246 0.0622419
R1086 VDD.n241 VDD.n207 0.0622419
R1087 VDD.n215 VDD.n214 0.0622419
R1088 VDD.n262 VDD.n245 0.0622419
R1089 VDD.n248 VDD.n247 0.0622419
R1090 VDD.n313 VDD.n299 0.0622419
R1091 VDD.n310 VDD.n300 0.0622419
R1092 VDD.n372 VDD.n362 0.0622419
R1093 VDD.n369 VDD.n363 0.0622419
R1094 VDD.n18 VDD.n17 0.0620047
R1095 VDD.n21 VDD.n16 0.0620047
R1096 VDD.n48 VDD.n46 0.0620047
R1097 VDD.n51 VDD.n45 0.0620047
R1098 VDD.n78 VDD.n76 0.0620047
R1099 VDD.n81 VDD.n75 0.0620047
R1100 VDD.n107 VDD.n105 0.0620047
R1101 VDD.n110 VDD.n104 0.0620047
R1102 VDD.n296 VDD.n189 0.0620047
R1103 VDD.n258 VDD.n246 0.0620047
R1104 VDD.n242 VDD.n207 0.0620047
R1105 VDD.n214 VDD.n208 0.0620047
R1106 VDD.n261 VDD.n245 0.0620047
R1107 VDD.n247 VDD.n190 0.0620047
R1108 VDD.n312 VDD.n299 0.0620047
R1109 VDD.n309 VDD.n300 0.0620047
R1110 VDD.n371 VDD.n362 0.0620047
R1111 VDD.n368 VDD.n363 0.0620047
R1112 VDD.n230 VDD.n229 0.0591957
R1113 VDD.n271 VDD.n270 0.0591957
R1114 VDD.n284 VDD.n283 0.0591957
R1115 VDD.n98 VDD.n74 0.0591957
R1116 VDD.n68 VDD.n44 0.0591957
R1117 VDD.n38 VDD.n15 0.0591957
R1118 VDD.n235 VDD.n234 0.0569545
R1119 VDD.n223 VDD.n222 0.0569545
R1120 VDD.n289 VDD.n288 0.0569545
R1121 VDD.n278 VDD.n277 0.0569545
R1122 VDD.n94 VDD.n93 0.0569545
R1123 VDD.n64 VDD.n63 0.0569545
R1124 VDD.n34 VDD.n33 0.0569545
R1125 VDD.n7 VDD.n6 0.0569545
R1126 VDD.n353 VDD.n352 0.0569545
R1127 VDD.n24 VDD.n23 0.0323
R1128 VDD.n28 VDD.n27 0.0323
R1129 VDD.n54 VDD.n53 0.0323
R1130 VDD.n58 VDD.n57 0.0323
R1131 VDD.n84 VDD.n83 0.0323
R1132 VDD.n88 VDD.n87 0.0323
R1133 VDD.n113 VDD.n112 0.0323
R1134 VDD.n117 VDD.n116 0.0323
R1135 VDD.n185 VDD.n184 0.0323
R1136 VDD.n188 VDD.n187 0.0323
R1137 VDD.n252 VDD.n251 0.0323
R1138 VDD.n256 VDD.n255 0.0323
R1139 VDD.n203 VDD.n202 0.0323
R1140 VDD.n206 VDD.n205 0.0323
R1141 VDD.n303 VDD.n302 0.0323
R1142 VDD.n306 VDD.n305 0.0323
R1143 VDD.n366 VDD.n365 0.0323
R1144 VDD.n350 VDD.n349 0.0323
R1145 VDD VDD.n346 0.0298562
R1146 VDD.n347 VDD 0.0147918
R1147 VDD.n380 VDD.n379 0.00965929
R1148 VDD.n235 VDD.n233 0.00919318
R1149 VDD.n225 VDD.n223 0.00919318
R1150 VDD.n289 VDD.n287 0.00919318
R1151 VDD.n279 VDD.n278 0.00919318
R1152 VDD.n101 VDD.n94 0.00919318
R1153 VDD.n71 VDD.n64 0.00919318
R1154 VDD.n41 VDD.n34 0.00919318
R1155 VDD.n12 VDD.n7 0.00919318
R1156 VDD.n353 VDD.n0 0.00919318
R1157 VDD.n264 VDD.n200 0.00205172
R1158 VDD.n269 VDD.n197 0.00205172
R1159 VDD.n315 VDD.n182 0.00205172
R1160 VDD.n329 VDD.n328 0.00205172
R1161 VDD.n335 VDD.n334 0.00205172
R1162 VDD.n341 VDD.n340 0.00205172
R1163 GND.n356 GND.n355 949975
R1164 GND.n445 GND.n444 737750
R1165 GND.n396 GND.n22 736938
R1166 GND.n490 GND.n489 607391
R1167 GND.n398 GND.n397 378058
R1168 GND.n855 GND.n23 374562
R1169 GND.n855 GND.n22 362375
R1170 GND.n397 GND.n396 260000
R1171 GND.n445 GND.n23 260000
R1172 GND.n530 GND.n356 139750
R1173 GND.n604 GND.n197 26433.3
R1174 GND.n604 GND.n602 26433.3
R1175 GND.n585 GND.n335 26433.3
R1176 GND.n670 GND.n150 26433.3
R1177 GND.n672 GND.n670 26433.3
R1178 GND.n405 GND.n335 26433.3
R1179 GND.n444 GND.n441 24808.3
R1180 GND.n403 GND.n22 24781.2
R1181 GND.n732 GND.n102 19955
R1182 GND.n114 GND.n105 15383.3
R1183 GND.n731 GND.n104 15383.3
R1184 GND.n682 GND.n98 15383.3
R1185 GND.n754 GND.n97 15383.3
R1186 GND.n494 GND.n492 15383.3
R1187 GND.n494 GND.n474 15383.3
R1188 GND.n448 GND.n23 15383.3
R1189 GND.n401 GND.n396 15383.3
R1190 GND.n399 GND.n397 15383.3
R1191 GND.n446 GND.n445 15383.3
R1192 GND.n711 GND.n110 14105
R1193 GND.n490 GND.n356 12232.4
R1194 GND.n530 GND.n529 8043.18
R1195 GND.n494 GND.n490 5522.69
R1196 GND.n449 GND.n22 4916.48
R1197 GND.n444 GND.n443 4901.02
R1198 GND.n732 GND.n103 3944.19
R1199 GND.n711 GND.n710 3883.6
R1200 GND.t414 GND.n4 3176.27
R1201 GND.n150 GND.n111 2648.63
R1202 GND.n710 GND.n111 2527.03
R1203 GND.n494 GND.n491 2032.7
R1204 GND.n494 GND.n493 1709.89
R1205 GND.n489 GND.n355 1314.18
R1206 GND.n489 GND.n488 1069.55
R1207 GND.n531 GND.n355 1064.66
R1208 GND.n529 GND.n357 930.226
R1209 GND.t967 GND.n708 894.625
R1210 GND.n531 GND.n530 875.908
R1211 GND.t945 GND.t935 870.856
R1212 GND.t424 GND.t274 870.856
R1213 GND.t422 GND.t273 870.856
R1214 GND.t435 GND.t272 870.856
R1215 GND.t932 GND.t0 870.856
R1216 GND.t909 GND.t919 870.856
R1217 GND.t61 GND.t171 870.856
R1218 GND.t60 GND.t169 870.856
R1219 GND.t59 GND.t446 870.856
R1220 GND.t906 GND.t145 870.856
R1221 GND.t883 GND.t893 870.856
R1222 GND.t255 GND.t177 870.856
R1223 GND.t254 GND.t175 870.856
R1224 GND.t253 GND.t155 870.856
R1225 GND.t880 GND.t312 870.856
R1226 GND.t867 GND.t857 870.856
R1227 GND.t308 GND.t236 870.856
R1228 GND.t306 GND.t235 870.856
R1229 GND.t295 GND.t234 870.856
R1230 GND.t1081 GND.t854 870.856
R1231 GND.n709 GND.t973 857.931
R1232 GND.n533 GND.n335 763.122
R1233 GND.n605 GND.n604 763.122
R1234 GND.n670 GND.n151 763.122
R1235 GND.t389 GND.t459 750.596
R1236 GND.n201 GND.n150 722.311
R1237 GND.n594 GND.n593 666.139
R1238 GND.t0 GND.t929 664.365
R1239 GND.t145 GND.t903 664.365
R1240 GND.t312 GND.t877 664.365
R1241 GND.t851 GND.t1081 664.365
R1242 GND.n647 GND.n111 628.453
R1243 GND.t973 GND.t967 615.054
R1244 GND.n710 GND.n709 585.35
R1245 GND.t1059 GND.t416 572.62
R1246 GND.t935 GND.n532 563.812
R1247 GND.n334 GND.t909 563.812
R1248 GND.n603 GND.t883 563.812
R1249 GND.n669 GND.t857 563.812
R1250 GND.t1065 GND.t1075 560.943
R1251 GND.t391 GND.t320 560.943
R1252 GND.t942 GND.n533 558.426
R1253 GND.t916 GND.n605 558.426
R1254 GND.t890 GND.n151 558.426
R1255 GND.n647 GND.t864 558.426
R1256 GND.n503 GND.n502 554.556
R1257 GND.t402 GND.t280 546.361
R1258 GND.t399 GND.t279 546.361
R1259 GND.t428 GND.t278 546.361
R1260 GND.t407 GND.t1036 546.361
R1261 GND.t1013 GND.t1023 546.361
R1262 GND.t67 GND.t163 546.361
R1263 GND.t66 GND.t165 546.361
R1264 GND.t65 GND.t451 546.361
R1265 GND.t395 GND.t1010 546.361
R1266 GND.t987 GND.t997 544.473
R1267 GND.t261 GND.t247 544.473
R1268 GND.t260 GND.t244 544.473
R1269 GND.t159 GND.t259 544.473
R1270 GND.t984 GND.t265 544.473
R1271 GND.t970 GND.t960 544.473
R1272 GND.t376 GND.t242 544.473
R1273 GND.t374 GND.t241 544.473
R1274 GND.t300 GND.t240 544.473
R1275 GND.t957 GND.t383 544.473
R1276 GND.n492 GND.t1062 512.263
R1277 GND.t390 GND.t318 509.498
R1278 GND.n405 GND.n404 478.771
R1279 GND.n440 GND.n197 477.116
R1280 GND.n672 GND.n671 477.116
R1281 GND.n528 GND.t1039 467.839
R1282 GND.n529 GND.n528 467.043
R1283 GND.n398 GND.t1039 462.998
R1284 GND.n674 GND.n112 454.3
R1285 GND.n680 GND.n142 454.3
R1286 GND.n451 GND.n394 454.3
R1287 GND.n668 GND.n152 454.3
R1288 GND.n656 GND.n173 454.3
R1289 GND.n606 GND.n196 454.3
R1290 GND.n559 GND.n353 454.3
R1291 GND.n527 GND.n358 454.3
R1292 GND.n515 GND.n473 454.3
R1293 GND.n708 GND.t237 447.312
R1294 GND.n674 GND.n116 446.601
R1295 GND.n684 GND.n142 446.601
R1296 GND.n451 GND.n395 446.601
R1297 GND.n668 GND.n153 446.601
R1298 GND.n659 GND.n173 446.601
R1299 GND.n609 GND.n196 446.601
R1300 GND.n562 GND.n353 446.601
R1301 GND.n527 GND.n359 446.601
R1302 GND.n518 GND.n473 446.601
R1303 GND.t270 GND.t269 404.007
R1304 GND.t269 GND.t926 404.007
R1305 GND.t57 GND.t56 404.007
R1306 GND.t56 GND.t900 404.007
R1307 GND.t251 GND.t250 404.007
R1308 GND.t250 GND.t874 404.007
R1309 GND.t231 GND.t232 404.007
R1310 GND.t848 GND.t231 404.007
R1311 GND.n561 GND.t271 396.824
R1312 GND.n608 GND.t58 396.824
R1313 GND.n658 GND.t252 396.824
R1314 GND.n645 GND.t233 396.824
R1315 GND.n707 GND.n116 378.7
R1316 GND.n684 GND.n143 378.7
R1317 GND.n439 GND.n395 378.7
R1318 GND.n648 GND.n153 378.7
R1319 GND.n659 GND.n158 378.7
R1320 GND.n609 GND.n179 378.7
R1321 GND.n562 GND.n354 378.7
R1322 GND.n388 GND.n359 378.7
R1323 GND.n518 GND.n366 378.7
R1324 GND.n560 GND.t432 375.276
R1325 GND.n607 GND.t444 375.276
R1326 GND.n657 GND.t151 375.276
R1327 GND.t292 GND.n646 375.276
R1328 GND.n707 GND.n112 371
R1329 GND.n680 GND.n143 371
R1330 GND.n439 GND.n394 371
R1331 GND.n648 GND.n152 371
R1332 GND.n656 GND.n158 371
R1333 GND.n606 GND.n179 371
R1334 GND.n559 GND.n354 371
R1335 GND.n388 GND.n358 371
R1336 GND.n515 GND.n366 371
R1337 GND.n491 GND.t1065 363.168
R1338 GND.t1033 GND.n403 353.726
R1339 GND.n441 GND.t1007 353.726
R1340 GND.t954 GND.n110 352.505
R1341 GND.n404 GND.t1046 350.348
R1342 GND.t1020 GND.n440 349.137
R1343 GND.n671 GND.t994 349.137
R1344 GND.n732 GND.n731 348.462
R1345 GND.t386 GND.t387 347.387
R1346 GND.t1056 GND.t386 347.387
R1347 GND.t981 GND.n102 346.892
R1348 GND.n449 GND.t1013 339.646
R1349 GND.n443 GND.t987 335.666
R1350 GND.t960 GND.n103 335.666
R1351 GND.n516 GND.t456 323.452
R1352 GND.n493 GND.t1072 294.894
R1353 GND.t929 GND.t2 278.315
R1354 GND.t903 GND.t143 278.315
R1355 GND.t877 GND.t314 278.315
R1356 GND.t1083 GND.t851 278.315
R1357 GND.n517 GND.n474 255.357
R1358 GND.t275 GND.t276 253.466
R1359 GND.t1030 GND.t275 253.466
R1360 GND.t62 GND.t1004 252.591
R1361 GND.t256 GND.t257 252.591
R1362 GND.t978 GND.t256 252.591
R1363 GND.n400 GND.t277 248.96
R1364 GND.t64 GND.n447 248.96
R1365 GND.n683 GND.t258 248.101
R1366 GND.n115 GND.t239 248.101
R1367 GND.t418 GND.t1059 239.881
R1368 GND.t416 GND.n492 238.333
R1369 GND.t430 GND.n402 235.442
R1370 GND.t442 GND.n406 235.442
R1371 GND.n681 GND.t149 234.63
R1372 GND.n113 GND.t298 234.63
R1373 GND.t63 GND.t62 231.462
R1374 GND.n335 GND.n334 224.447
R1375 GND.n604 GND.n603 224.447
R1376 GND.n670 GND.n669 224.447
R1377 GND.n709 GND.t238 208.809
R1378 GND.n855 GND.t413 204.232
R1379 GND.n755 GND.n754 190.769
R1380 GND.n493 GND.n357 185.274
R1381 GND.t405 GND.t1033 174.611
R1382 GND.t1007 GND.t393 174.611
R1383 GND.t263 GND.t981 174.007
R1384 GND.t380 GND.t954 174.007
R1385 GND.n507 GND.n487 165.667
R1386 GND.n450 GND.n405 140.815
R1387 GND.n442 GND.n197 140.328
R1388 GND.n673 GND.n672 140.328
R1389 GND.t2 GND.t270 125.692
R1390 GND.t143 GND.t57 125.692
R1391 GND.t314 GND.t251 125.692
R1392 GND.t232 GND.t1083 125.692
R1393 GND.n746 GND.n732 118.463
R1394 GND.t414 GND.n876 112.308
R1395 GND.t413 GND.n24 112.308
R1396 GND.n561 GND.n560 98.7574
R1397 GND.n608 GND.n607 98.7574
R1398 GND.n658 GND.n657 98.7574
R1399 GND.n646 GND.n645 98.7574
R1400 GND.t392 GND.n494 98.16
R1401 GND.t412 GND.n98 96.1544
R1402 GND.t411 GND.n105 96.1544
R1403 GND.n506 GND.t415 90.4913
R1404 GND.t415 GND.n505 90.4913
R1405 GND.n504 GND.t290 90.4913
R1406 GND.t290 GND.n4 90.4913
R1407 GND.n532 GND.n531 89.7795
R1408 GND.t388 GND.n474 86.6672
R1409 GND.n517 GND.n516 85.1195
R1410 GND.t1049 GND.n398 83.3627
R1411 GND.n770 GND.n769 79.2313
R1412 GND.t276 GND.t405 78.8567
R1413 GND.t393 GND.t63 78.8567
R1414 GND.t257 GND.t263 78.5843
R1415 GND.t238 GND.t380 78.5843
R1416 GND.n724 GND.n712 78.1672
R1417 GND.n720 GND.n716 78.1672
R1418 GND.n745 GND.n733 78.1672
R1419 GND.n741 GND.n737 78.1672
R1420 GND.n768 GND.n758 78.1672
R1421 GND.n764 GND.n761 78.1672
R1422 GND.n868 GND.n867 78.1672
R1423 GND.n875 GND.n5 78.1672
R1424 GND.n506 GND.t392 73.6201
R1425 GND.t274 GND.t945 71.8237
R1426 GND.t273 GND.t424 71.8237
R1427 GND.t272 GND.t422 71.8237
R1428 GND.t271 GND.t435 71.8237
R1429 GND.t432 GND.t932 71.8237
R1430 GND.t919 GND.t61 71.8237
R1431 GND.t171 GND.t60 71.8237
R1432 GND.t169 GND.t59 71.8237
R1433 GND.t446 GND.t58 71.8237
R1434 GND.t444 GND.t906 71.8237
R1435 GND.t893 GND.t255 71.8237
R1436 GND.t177 GND.t254 71.8237
R1437 GND.t175 GND.t253 71.8237
R1438 GND.t155 GND.t252 71.8237
R1439 GND.t151 GND.t880 71.8237
R1440 GND.t236 GND.t867 71.8237
R1441 GND.t235 GND.t308 71.8237
R1442 GND.t234 GND.t306 71.8237
R1443 GND.t233 GND.t295 71.8237
R1444 GND.t854 GND.t292 71.8237
R1445 GND.t265 GND.n102 68.4806
R1446 GND.n403 GND.t407 63.0854
R1447 GND.n441 GND.t395 63.0854
R1448 GND.t383 GND.n110 62.8675
R1449 GND.t459 GND.t388 61.9053
R1450 GND.t1062 GND.t456 61.9053
R1451 GND.n683 GND.n682 56.1318
R1452 GND.t387 GND.t418 54.1028
R1453 GND.n869 GND.n866 53.8467
R1454 GND.n505 GND.n504 53.6815
R1455 GND.n401 GND.n400 50.6937
R1456 GND.n447 GND.n446 50.6937
R1457 GND.n115 GND.n114 50.5186
R1458 GND.t1075 GND.t391 46.2638
R1459 GND.t320 GND.t390 46.2638
R1460 GND.n876 GND.t281 45.3851
R1461 GND.n13 GND.t281 45.3851
R1462 GND.t438 GND.n869 45.3851
R1463 GND.t68 GND.n24 45.3851
R1464 GND.n763 GND.t68 45.3851
R1465 GND.n769 GND.t454 45.3851
R1466 GND.t262 GND.n738 45.3851
R1467 GND.n740 GND.t262 45.3851
R1468 GND.n739 GND.t153 45.3851
R1469 GND.t243 GND.n717 45.3851
R1470 GND.n719 GND.t243 45.3851
R1471 GND.n718 GND.t304 45.3851
R1472 GND.t280 GND.t1049 45.0612
R1473 GND.t279 GND.t402 45.0612
R1474 GND.t277 GND.t428 45.0612
R1475 GND.t1036 GND.t430 45.0612
R1476 GND.t1023 GND.t67 45.0612
R1477 GND.t163 GND.t66 45.0612
R1478 GND.t451 GND.t64 45.0612
R1479 GND.t1010 GND.t442 45.0612
R1480 GND.t997 GND.t261 44.9055
R1481 GND.t247 GND.t260 44.9055
R1482 GND.t258 GND.t159 44.9055
R1483 GND.t149 GND.t984 44.9055
R1484 GND.t242 GND.t970 44.9055
R1485 GND.t241 GND.t376 44.9055
R1486 GND.t239 GND.t300 44.9055
R1487 GND.t298 GND.t957 44.9055
R1488 GND.n776 GND.n775 44.1394
R1489 GND.n772 GND.n771 44.1394
R1490 GND.n860 GND.n19 44.1394
R1491 GND.n865 GND.n15 44.1394
R1492 GND.n600 GND.n200 44.1394
R1493 GND.n596 GND.n205 44.1394
R1494 GND.n592 GND.n206 44.1394
R1495 GND.n588 GND.n333 44.1394
R1496 GND.n582 GND.n336 44.1394
R1497 GND.n709 GND.t237 43.7829
R1498 GND.t282 GND.n14 41.539
R1499 GND.n762 GND.t288 41.539
R1500 GND.t244 GND.n97 40.415
R1501 GND.n856 GND.n855 38.0774
R1502 GND.n399 GND.t399 34.9225
R1503 GND.t165 GND.n448 34.9225
R1504 GND.n104 GND.t374 34.8019
R1505 GND.n584 GND.n583 33.2283
R1506 GND.n587 GND.n586 33.2283
R1507 GND.n595 GND.n198 33.2283
R1508 GND.n601 GND.n199 33.2283
R1509 GND.n14 GND.n13 32.3082
R1510 GND.n21 GND.n20 32.3082
R1511 GND.n859 GND.n858 32.3082
R1512 GND.n763 GND.n762 32.3082
R1513 GND.n774 GND.n773 32.3082
R1514 GND.n778 GND.n777 32.3082
R1515 GND.n740 GND.n739 32.3082
R1516 GND.n719 GND.n718 32.3082
R1517 GND.t286 GND.n746 30.0005
R1518 GND.t284 GND.n725 30.0005
R1519 GND.n754 GND.t412 26.9236
R1520 GND.n731 GND.t411 26.9236
R1521 GND.t318 GND.t389 26.4771
R1522 GND.n488 GND.t137 22.9435
R1523 GND.n583 GND.t137 22.9435
R1524 GND.t127 GND.n584 22.9435
R1525 GND.n586 GND.t123 22.9435
R1526 GND.n593 GND.t123 22.9435
R1527 GND.t135 GND.n594 22.9435
R1528 GND.n595 GND.t135 22.9435
R1529 GND.t133 GND.n601 22.9435
R1530 GND.t119 GND.n199 22.9435
R1531 GND.n201 GND.t119 22.9435
R1532 GND.n866 GND.t139 22.3082
R1533 GND.n20 GND.t139 22.3082
R1534 GND.t129 GND.n21 22.3082
R1535 GND.n859 GND.t129 22.3082
R1536 GND.n858 GND.t125 22.3082
R1537 GND.n856 GND.t125 22.3082
R1538 GND.n770 GND.t141 22.3082
R1539 GND.n773 GND.t141 22.3082
R1540 GND.n774 GND.t131 22.3082
R1541 GND.n777 GND.t131 22.3082
R1542 GND.n778 GND.t121 22.3082
R1543 GND.t121 GND.n755 22.3082
R1544 GND.n602 GND.t133 19.779
R1545 GND.n443 GND.n442 16.8399
R1546 GND.n673 GND.n103 16.8399
R1547 GND.n587 GND.n585 16.6144
R1548 GND.n738 GND.n98 16.1543
R1549 GND.n717 GND.n105 16.1543
R1550 GND.t286 GND.t153 15.3851
R1551 GND.t284 GND.t304 15.3851
R1552 GND.n725 GND.n711 14.6159
R1553 GND.n450 GND.n449 14.082
R1554 GND.n402 GND.n401 11.2657
R1555 GND.n446 GND.n406 11.2657
R1556 GND.n114 GND.n113 11.2268
R1557 GND.t278 GND.n399 10.1391
R1558 GND.n448 GND.t65 10.1391
R1559 GND.t240 GND.n104 10.1041
R1560 GND.n701 GND.t953 9.74426
R1561 GND.n129 GND.t980 9.74426
R1562 GND.n414 GND.t1006 9.74426
R1563 GND.n380 GND.t1032 9.74426
R1564 GND.n368 GND.t1058 9.74426
R1565 GND.n625 GND.t850 9.74426
R1566 GND.n160 GND.t876 9.74426
R1567 GND.n181 GND.t902 9.74426
R1568 GND.n539 GND.t928 9.74426
R1569 GND.n117 GND.t962 9.70368
R1570 GND.n147 GND.t989 9.70368
R1571 GND.n407 GND.t1015 9.70368
R1572 GND.n384 GND.t1041 9.70368
R1573 GND.n360 GND.t1067 9.70368
R1574 GND.n621 GND.t859 9.70368
R1575 GND.n154 GND.t885 9.70368
R1576 GND.n176 GND.t911 9.70368
R1577 GND.n535 GND.t937 9.70368
R1578 GND.n757 GND.t142 9.701
R1579 GND.n864 GND.t140 9.701
R1580 GND.n117 GND.t951 9.70093
R1581 GND.n147 GND.t977 9.70093
R1582 GND.n407 GND.t1003 9.70093
R1583 GND.n384 GND.t1029 9.70093
R1584 GND.n360 GND.t1055 9.70093
R1585 GND.n621 GND.t847 9.70093
R1586 GND.n154 GND.t873 9.70093
R1587 GND.n176 GND.t899 9.70093
R1588 GND.n535 GND.t925 9.70093
R1589 GND.n704 GND.t964 9.6945
R1590 GND.n132 GND.t991 9.6945
R1591 GND.n417 GND.t1017 9.6945
R1592 GND.n383 GND.t1043 9.6945
R1593 GND.n371 GND.t1069 9.6945
R1594 GND.n628 GND.t861 9.6945
R1595 GND.n163 GND.t887 9.6945
R1596 GND.n184 GND.t913 9.6945
R1597 GND.n542 GND.t939 9.6945
R1598 GND.n756 GND.t132 9.6803
R1599 GND.n18 GND.t130 9.6803
R1600 GND.n780 GND.t122 9.6803
R1601 GND.n17 GND.t126 9.6803
R1602 GND.n203 GND.t120 9.6803
R1603 GND.n598 GND.t134 9.6803
R1604 GND.n204 GND.t136 9.6803
R1605 GND.n590 GND.t124 9.6803
R1606 GND.n332 GND.t128 9.6803
R1607 GND.n580 GND.t138 9.6803
R1608 GND.n511 GND.n0 9.59334
R1609 GND.n464 GND.t1050 9.58962
R1610 GND.n464 GND.t1054 9.58962
R1611 GND.t1028 GND.n378 9.58962
R1612 GND.t1024 GND.n378 9.58962
R1613 GND.n420 GND.t998 9.58962
R1614 GND.n420 GND.t1002 9.58962
R1615 GND.n691 GND.t976 9.58962
R1616 GND.n691 GND.t971 9.58962
R1617 GND.n567 GND.t950 9.58962
R1618 GND.n567 GND.t946 9.58962
R1619 GND.n545 GND.t920 9.58962
R1620 GND.n545 GND.t924 9.58962
R1621 GND.n187 GND.t898 9.58962
R1622 GND.n187 GND.t894 9.58962
R1623 GND.t868 GND.n164 9.58962
R1624 GND.t872 GND.n164 9.58962
R1625 GND.n479 GND.t1076 9.58962
R1626 GND.n481 GND.t1080 9.58962
R1627 GND.n462 GND.t1054 9.58587
R1628 GND.n462 GND.t1050 9.58587
R1629 GND.n429 GND.t1028 9.58587
R1630 GND.n429 GND.t1024 9.58587
R1631 GND.n418 GND.t1002 9.58587
R1632 GND.n418 GND.t998 9.58587
R1633 GND.n693 GND.t976 9.58587
R1634 GND.n693 GND.t971 9.58587
R1635 GND.n565 GND.t950 9.58587
R1636 GND.n565 GND.t946 9.58587
R1637 GND.n543 GND.t924 9.58587
R1638 GND.n543 GND.t920 9.58587
R1639 GND.n185 GND.t898 9.58587
R1640 GND.n185 GND.t894 9.58587
R1641 GND.n637 GND.t872 9.58587
R1642 GND.n637 GND.t868 9.58587
R1643 GND.t1080 GND.n476 9.58587
R1644 GND.t1076 GND.n477 9.58587
R1645 GND.t1078 GND.n522 9.58025
R1646 GND.n522 GND.t1073 9.58025
R1647 GND.n457 GND.t1047 9.58025
R1648 GND.n457 GND.t1052 9.58025
R1649 GND.t1026 GND.n434 9.58025
R1650 GND.n434 GND.t1021 9.58025
R1651 GND.t995 GND.n688 9.58025
R1652 GND.n688 GND.t1000 9.58025
R1653 GND.t974 GND.n698 9.58025
R1654 GND.n698 GND.t968 9.58025
R1655 GND.t948 GND.n550 9.58025
R1656 GND.n550 GND.t943 9.58025
R1657 GND.t917 GND.n613 9.58025
R1658 GND.n613 GND.t922 9.58025
R1659 GND.t896 GND.n663 9.58025
R1660 GND.n663 GND.t891 9.58025
R1661 GND.t865 GND.n642 9.58025
R1662 GND.n642 GND.t870 9.58025
R1663 GND.n523 GND.t1073 9.5765
R1664 GND.n523 GND.t1078 9.5765
R1665 GND.n470 GND.t319 9.5765
R1666 GND.n470 GND.t321 9.5765
R1667 GND.n471 GND.t322 9.5765
R1668 GND.n471 GND.t323 9.5765
R1669 GND.n468 GND.t458 9.5765
R1670 GND.n468 GND.t460 9.5765
R1671 GND.n469 GND.t457 9.5765
R1672 GND.n469 GND.t461 9.5765
R1673 GND.n466 GND.t420 9.5765
R1674 GND.n466 GND.t417 9.5765
R1675 GND.n467 GND.t419 9.5765
R1676 GND.n467 GND.t421 9.5765
R1677 GND.n455 GND.t1047 9.5765
R1678 GND.n435 GND.t1021 9.5765
R1679 GND.n435 GND.t1026 9.5765
R1680 GND.n426 GND.t167 9.5765
R1681 GND.n426 GND.t164 9.5765
R1682 GND.n427 GND.t166 9.5765
R1683 GND.n427 GND.t168 9.5765
R1684 GND.n424 GND.t450 9.5765
R1685 GND.n424 GND.t452 9.5765
R1686 GND.n425 GND.t443 9.5765
R1687 GND.n425 GND.t453 9.5765
R1688 GND.n422 GND.t394 9.5765
R1689 GND.n422 GND.t396 9.5765
R1690 GND.n423 GND.t397 9.5765
R1691 GND.n423 GND.t398 9.5765
R1692 GND.n689 GND.t995 9.5765
R1693 GND.n699 GND.t968 9.5765
R1694 GND.n699 GND.t974 9.5765
R1695 GND.n126 GND.t375 9.5765
R1696 GND.n126 GND.t377 9.5765
R1697 GND.n127 GND.t378 9.5765
R1698 GND.n127 GND.t379 9.5765
R1699 GND.n124 GND.t299 9.5765
R1700 GND.n124 GND.t302 9.5765
R1701 GND.n125 GND.t303 9.5765
R1702 GND.n125 GND.t301 9.5765
R1703 GND.n122 GND.t382 9.5765
R1704 GND.n122 GND.t384 9.5765
R1705 GND.n123 GND.t381 9.5765
R1706 GND.n123 GND.t385 9.5765
R1707 GND.n689 GND.t1000 9.5765
R1708 GND.n139 GND.t246 9.5765
R1709 GND.n139 GND.t248 9.5765
R1710 GND.n140 GND.t245 9.5765
R1711 GND.n140 GND.t249 9.5765
R1712 GND.n137 GND.t150 9.5765
R1713 GND.n137 GND.t161 9.5765
R1714 GND.n138 GND.t162 9.5765
R1715 GND.n138 GND.t160 9.5765
R1716 GND.n135 GND.t264 9.5765
R1717 GND.n135 GND.t266 9.5765
R1718 GND.n136 GND.t267 9.5765
R1719 GND.n136 GND.t268 9.5765
R1720 GND.n455 GND.t1052 9.5765
R1721 GND.n372 GND.t401 9.5765
R1722 GND.n372 GND.t403 9.5765
R1723 GND.n373 GND.t400 9.5765
R1724 GND.n373 GND.t404 9.5765
R1725 GND.n374 GND.t440 9.5765
R1726 GND.n374 GND.t429 9.5765
R1727 GND.n375 GND.t431 9.5765
R1728 GND.n375 GND.t441 9.5765
R1729 GND.n376 GND.t406 9.5765
R1730 GND.n376 GND.t409 9.5765
R1731 GND.n377 GND.t410 9.5765
R1732 GND.n377 GND.t408 9.5765
R1733 GND.n551 GND.t943 9.5765
R1734 GND.n551 GND.t948 9.5765
R1735 GND.n348 GND.t423 9.5765
R1736 GND.n348 GND.t425 9.5765
R1737 GND.n349 GND.t426 9.5765
R1738 GND.n349 GND.t427 9.5765
R1739 GND.n350 GND.t434 9.5765
R1740 GND.n350 GND.t436 9.5765
R1741 GND.n351 GND.t433 9.5765
R1742 GND.n351 GND.t437 9.5765
R1743 GND.n547 GND.t4 9.5765
R1744 GND.n547 GND.t1 9.5765
R1745 GND.n548 GND.t3 9.5765
R1746 GND.n548 GND.t5 9.5765
R1747 GND.n614 GND.t917 9.5765
R1748 GND.n664 GND.t891 9.5765
R1749 GND.n664 GND.t896 9.5765
R1750 GND.n170 GND.t176 9.5765
R1751 GND.n170 GND.t179 9.5765
R1752 GND.n171 GND.t180 9.5765
R1753 GND.n171 GND.t178 9.5765
R1754 GND.n168 GND.t152 9.5765
R1755 GND.n168 GND.t156 9.5765
R1756 GND.n169 GND.t157 9.5765
R1757 GND.n169 GND.t158 9.5765
R1758 GND.n166 GND.t316 9.5765
R1759 GND.n166 GND.t313 9.5765
R1760 GND.n167 GND.t315 9.5765
R1761 GND.n167 GND.t317 9.5765
R1762 GND.n643 GND.t865 9.5765
R1763 GND.n643 GND.t870 9.5765
R1764 GND.n634 GND.t307 9.5765
R1765 GND.n634 GND.t309 9.5765
R1766 GND.n635 GND.t310 9.5765
R1767 GND.n635 GND.t311 9.5765
R1768 GND.n632 GND.t294 9.5765
R1769 GND.n632 GND.t296 9.5765
R1770 GND.n633 GND.t293 9.5765
R1771 GND.n633 GND.t297 9.5765
R1772 GND.n630 GND.t1085 9.5765
R1773 GND.n630 GND.t1082 9.5765
R1774 GND.n631 GND.t1084 9.5765
R1775 GND.n631 GND.t1086 9.5765
R1776 GND.n614 GND.t922 9.5765
R1777 GND.n193 GND.t170 9.5765
R1778 GND.n193 GND.t172 9.5765
R1779 GND.n194 GND.t173 9.5765
R1780 GND.n194 GND.t174 9.5765
R1781 GND.n191 GND.t445 9.5765
R1782 GND.n191 GND.t448 9.5765
R1783 GND.n192 GND.t449 9.5765
R1784 GND.n192 GND.t447 9.5765
R1785 GND.n189 GND.t144 9.5765
R1786 GND.n189 GND.t146 9.5765
R1787 GND.n190 GND.t147 9.5765
R1788 GND.n190 GND.t148 9.5765
R1789 GND.t926 GND.t942 8.9784
R1790 GND.t900 GND.t916 8.9784
R1791 GND.t874 GND.t890 8.9784
R1792 GND.t864 GND.t848 8.9784
R1793 GND.n514 GND.n513 8.5805
R1794 GND.n558 GND.n345 8.07104
R1795 GND.n678 GND.n145 8.0255
R1796 GND.n679 GND.n144 8.0255
R1797 GND.n393 GND.n392 8.0255
R1798 GND.n389 GND.n347 8.0255
R1799 GND.n654 GND.n651 8.0255
R1800 GND.n655 GND.n620 8.0255
R1801 GND.n557 GND.n174 8.0255
R1802 GND.t1072 GND.t1056 7.72021
R1803 GND.n145 GND.n120 6.7655
R1804 GND.n651 GND.n650 6.7655
R1805 GND.n585 GND.t127 6.32961
R1806 GND.n679 GND.n678 6.2405
R1807 GND.n393 GND.n144 6.2405
R1808 GND.n392 GND.n389 6.2405
R1809 GND.n655 GND.n654 6.2405
R1810 GND.n620 GND.n174 6.2405
R1811 GND.n558 GND.n557 6.2405
R1812 GND.n514 GND.n347 6.2405
R1813 GND.n501 GND.t462 5.68598
R1814 GND.t1046 GND.t1030 5.63308
R1815 GND.t1004 GND.t1020 5.61363
R1816 GND.n682 GND.n681 5.61363
R1817 GND.t994 GND.t978 5.61363
R1818 GND.n89 GND.n88 5.60179
R1819 GND.n10 GND.n9 5.32713
R1820 GND.n723 GND.n713 5.32713
R1821 GND.n744 GND.n734 5.32713
R1822 GND.n767 GND.n766 5.32713
R1823 GND.n872 GND.n10 4.86731
R1824 GND.n767 GND.n93 4.86731
R1825 GND.n118 GND.t963 4.79493
R1826 GND.t952 GND.n118 4.79493
R1827 GND.n148 GND.t990 4.79493
R1828 GND.t979 GND.n148 4.79493
R1829 GND.n408 GND.t1016 4.79493
R1830 GND.t1005 GND.n408 4.79493
R1831 GND.n385 GND.t1042 4.79493
R1832 GND.t1031 GND.n385 4.79493
R1833 GND.n361 GND.t1068 4.79493
R1834 GND.t1057 GND.n361 4.79493
R1835 GND.n622 GND.t860 4.79493
R1836 GND.t849 GND.n622 4.79493
R1837 GND.n155 GND.t886 4.79493
R1838 GND.t875 GND.n155 4.79493
R1839 GND.n177 GND.t912 4.79493
R1840 GND.t901 GND.n177 4.79493
R1841 GND.n536 GND.t938 4.79493
R1842 GND.t927 GND.n536 4.79493
R1843 GND.n723 GND.n722 4.79348
R1844 GND.n744 GND.n743 4.79348
R1845 GND.n390 GND.t1014 4.789
R1846 GND.n146 GND.t961 4.789
R1847 GND.n410 GND.t988 4.789
R1848 GND.n363 GND.t1040 4.789
R1849 GND.n344 GND.t936 4.789
R1850 GND.n175 GND.t884 4.789
R1851 GND.n652 GND.t858 4.789
R1852 GND.n534 GND.t910 4.789
R1853 GND.n475 GND.t1066 4.789
R1854 GND.n700 GND.t958 4.789
R1855 GND.n128 GND.t985 4.789
R1856 GND.n413 GND.t1011 4.789
R1857 GND.n379 GND.t1037 4.789
R1858 GND.n367 GND.t1063 4.789
R1859 GND.n624 GND.t855 4.789
R1860 GND.n159 GND.t881 4.789
R1861 GND.n180 GND.t907 4.789
R1862 GND.n538 GND.t933 4.789
R1863 GND.n10 GND.t439 4.7885
R1864 GND.n767 GND.t455 4.7885
R1865 GND.n723 GND.t305 4.7885
R1866 GND.n744 GND.t154 4.7885
R1867 GND.n119 GND.t952 4.7885
R1868 GND.n119 GND.t963 4.7885
R1869 GND.n149 GND.t979 4.7885
R1870 GND.n149 GND.t990 4.7885
R1871 GND.n409 GND.t1005 4.7885
R1872 GND.n409 GND.t1016 4.7885
R1873 GND.n386 GND.t1031 4.7885
R1874 GND.n386 GND.t1042 4.7885
R1875 GND.n362 GND.t1057 4.7885
R1876 GND.n362 GND.t1068 4.7885
R1877 GND.n623 GND.t849 4.7885
R1878 GND.n623 GND.t860 4.7885
R1879 GND.n156 GND.t875 4.7885
R1880 GND.n156 GND.t886 4.7885
R1881 GND.n178 GND.t901 4.7885
R1882 GND.n178 GND.t912 4.7885
R1883 GND.n537 GND.t927 4.7885
R1884 GND.n537 GND.t938 4.7885
R1885 GND.n497 GND.t1087 4.74041
R1886 GND.n6 GND.t1088 4.74041
R1887 GND.n714 GND.t1091 4.74041
R1888 GND.n735 GND.t1090 4.74041
R1889 GND.n759 GND.t1089 4.74041
R1890 GND.n846 GND.n845 4.5005
R1891 GND.n845 GND.n92 4.5005
R1892 GND.n577 GND.n576 4.5005
R1893 GND.n339 GND.n338 4.5005
R1894 GND.n576 GND.n338 4.5005
R1895 GND.n576 GND.n575 4.5005
R1896 GND.t259 GND.n97 4.491
R1897 GND.n879 GND.n2 4.48222
R1898 GND.n509 GND.n508 4.47312
R1899 GND.n880 GND.n1 4.43415
R1900 GND.n3 GND.n2 4.41637
R1901 GND.n729 GND.n107 4.41637
R1902 GND.n729 GND.n728 4.41637
R1903 GND.n752 GND.n751 4.41637
R1904 GND.n752 GND.n94 4.41637
R1905 GND.n853 GND.n852 4.41637
R1906 GND.n853 GND.n90 4.41637
R1907 GND.n779 GND.n755 4.14284
R1908 GND.n857 GND.n856 4.14284
R1909 GND.n202 GND.n201 4.14284
R1910 GND.t282 GND.t438 3.84665
R1911 GND.t454 GND.t288 3.84665
R1912 GND.n512 GND.n511 3.66165
R1913 GND.n267 GND.n266 3.56945
R1914 GND.n331 GND.n330 3.56945
R1915 GND.n107 GND.n101 3.38193
R1916 GND.n779 GND.n778 3.31164
R1917 GND.n858 GND.n857 3.31164
R1918 GND.n202 GND.n199 3.31164
R1919 GND.n602 GND.n198 3.16506
R1920 GND.n848 GND.n847 2.7093
R1921 GND.n871 GND.n11 2.68974
R1922 GND.n747 GND.n101 2.61148
R1923 GND.n498 GND.n495 2.55915
R1924 GND.n496 GND.n495 2.55915
R1925 GND.n702 GND.t955 2.40358
R1926 GND.n130 GND.t982 2.40358
R1927 GND.n415 GND.t1008 2.40358
R1928 GND.n381 GND.t1034 2.40358
R1929 GND.n369 GND.t1060 2.40358
R1930 GND.n626 GND.t852 2.40358
R1931 GND.n161 GND.t878 2.40358
R1932 GND.n182 GND.t904 2.40358
R1933 GND.n540 GND.t930 2.40358
R1934 GND.n703 GND.t965 2.3984
R1935 GND.n131 GND.t992 2.3984
R1936 GND.n416 GND.t1018 2.3984
R1937 GND.n382 GND.t1044 2.3984
R1938 GND.n370 GND.t1070 2.3984
R1939 GND.n627 GND.t862 2.3984
R1940 GND.n162 GND.t888 2.3984
R1941 GND.n183 GND.t914 2.3984
R1942 GND.n541 GND.t940 2.3984
R1943 GND GND.n880 2.38285
R1944 GND.n266 GND.n207 2.2955
R1945 GND.n330 GND.n268 2.2955
R1946 GND.n88 GND.n87 2.28942
R1947 GND.n844 GND.n843 2.2865
R1948 GND.n874 GND.n873 2.28311
R1949 GND.n722 GND.n715 2.28311
R1950 GND.n743 GND.n736 2.28311
R1951 GND.n760 GND.n91 2.28311
R1952 GND.n86 GND.n26 2.25175
R1953 GND.n835 GND.n834 2.25175
R1954 GND.n265 GND.n264 2.25175
R1955 GND.n328 GND.n268 2.25175
R1956 GND.n87 GND.n86 2.251
R1957 GND.n834 GND.n784 2.251
R1958 GND.n264 GND.n207 2.251
R1959 GND.n329 GND.n328 2.251
R1960 GND.n88 GND.n26 2.2505
R1961 GND.n844 GND.n783 2.2505
R1962 GND.n266 GND.n265 2.2505
R1963 GND.n330 GND.n329 2.2505
R1964 GND.n342 GND.n341 2.24585
R1965 GND.n579 GND.n578 2.24585
R1966 GND.n577 GND.n340 2.24468
R1967 GND.n575 GND.n337 2.24468
R1968 GND.n485 GND.n1 2.24034
R1969 GND.n500 GND.n499 2.1876
R1970 GND.n845 GND.n844 2.14881
R1971 GND.n390 GND.t1012 2.12328
R1972 GND.n146 GND.t959 2.12328
R1973 GND.n700 GND.t956 2.12328
R1974 GND.n128 GND.t983 2.12328
R1975 GND.n410 GND.t986 2.12328
R1976 GND.n413 GND.t1009 2.12328
R1977 GND.n379 GND.t1035 2.12328
R1978 GND.n363 GND.t1038 2.12328
R1979 GND.n367 GND.t1061 2.12328
R1980 GND.n344 GND.t934 2.12328
R1981 GND.n175 GND.t882 2.12328
R1982 GND.n624 GND.t853 2.12328
R1983 GND.n652 GND.t856 2.12328
R1984 GND.n159 GND.t879 2.12328
R1985 GND.n180 GND.t905 2.12328
R1986 GND.n534 GND.t908 2.12328
R1987 GND.n538 GND.t931 2.12328
R1988 GND.n475 GND.t1064 2.12328
R1989 GND.n727 GND.n108 2.10376
R1990 GND.n750 GND.n100 2.10376
R1991 GND.n873 GND.n8 1.99391
R1992 GND.n851 GND.n91 1.99391
R1993 GND.n463 GND.t1048 1.96933
R1994 GND.n428 GND.t1022 1.96933
R1995 GND.n419 GND.t996 1.96933
R1996 GND.n692 GND.t969 1.96933
R1997 GND.n566 GND.t944 1.96933
R1998 GND.n544 GND.t918 1.96933
R1999 GND.n186 GND.t892 1.96933
R2000 GND.n636 GND.t866 1.96933
R2001 GND.n465 GND.t1071 1.9682
R2002 GND.n421 GND.t1019 1.9682
R2003 GND.n121 GND.t966 1.9682
R2004 GND.n134 GND.t993 1.9682
R2005 GND.n456 GND.t1045 1.9682
R2006 GND.n546 GND.t941 1.9682
R2007 GND.n165 GND.t889 1.9682
R2008 GND.n629 GND.t863 1.9682
R2009 GND.n188 GND.t915 1.9682
R2010 GND.n465 GND.t1077 1.96775
R2011 GND.n463 GND.t1053 1.96775
R2012 GND.n421 GND.t1025 1.96775
R2013 GND.n428 GND.t1027 1.96775
R2014 GND.n419 GND.t1001 1.96775
R2015 GND.n121 GND.t972 1.96775
R2016 GND.n692 GND.t975 1.96775
R2017 GND.n134 GND.t999 1.96775
R2018 GND.n456 GND.t1051 1.96775
R2019 GND.n546 GND.t947 1.96775
R2020 GND.n566 GND.t949 1.96775
R2021 GND.n544 GND.t923 1.96775
R2022 GND.n165 GND.t895 1.96775
R2023 GND.n186 GND.t897 1.96775
R2024 GND.n636 GND.t871 1.96775
R2025 GND.n629 GND.t869 1.96775
R2026 GND.n188 GND.t921 1.96775
R2027 GND.n482 GND.t1079 1.96775
R2028 GND.n478 GND.t1074 1.96775
R2029 GND.n880 GND.n879 1.96348
R2030 GND.n580 GND.n579 1.93161
R2031 GND.n109 GND.t285 1.9157
R2032 GND.n747 GND.t287 1.9157
R2033 GND.n776 GND.n96 1.76752
R2034 GND.n861 GND.n860 1.76752
R2035 GND.n705 GND.n704 1.7455
R2036 GND.n644 GND.n628 1.7455
R2037 GND.n580 GND.n336 1.73383
R2038 GND.n488 GND.n336 1.73383
R2039 GND.n582 GND.n581 1.73383
R2040 GND.n583 GND.n582 1.73383
R2041 GND.n333 GND.n332 1.73383
R2042 GND.n584 GND.n333 1.73383
R2043 GND.n589 GND.n588 1.73383
R2044 GND.n588 GND.n587 1.73383
R2045 GND.n590 GND.n206 1.73383
R2046 GND.n586 GND.n206 1.73383
R2047 GND.n592 GND.n591 1.73383
R2048 GND.n593 GND.n592 1.73383
R2049 GND.n205 GND.n204 1.73383
R2050 GND.n594 GND.n205 1.73383
R2051 GND.n597 GND.n596 1.73383
R2052 GND.n596 GND.n595 1.73383
R2053 GND.n598 GND.n200 1.73383
R2054 GND.n200 GND.n198 1.73383
R2055 GND.n600 GND.n599 1.73383
R2056 GND.n601 GND.n600 1.73383
R2057 GND.n865 GND.n864 1.73383
R2058 GND.n866 GND.n865 1.73383
R2059 GND.n863 GND.n15 1.73383
R2060 GND.n20 GND.n15 1.73383
R2061 GND.n19 GND.n18 1.73383
R2062 GND.n21 GND.n19 1.73383
R2063 GND.n860 GND.n859 1.73383
R2064 GND.n771 GND.n757 1.73383
R2065 GND.n771 GND.n770 1.73383
R2066 GND.n772 GND.n95 1.73383
R2067 GND.n773 GND.n772 1.73383
R2068 GND.n775 GND.n756 1.73383
R2069 GND.n775 GND.n774 1.73383
R2070 GND.n777 GND.n776 1.73383
R2071 GND.n133 GND.n132 1.7185
R2072 GND.n437 GND.n417 1.7185
R2073 GND.n453 GND.n383 1.7185
R2074 GND.n525 GND.n371 1.7185
R2075 GND.n666 GND.n163 1.7185
R2076 GND.n616 GND.n184 1.7185
R2077 GND.n553 GND.n542 1.7185
R2078 GND.n782 GND.n94 1.70309
R2079 GND.n705 GND.n699 1.47702
R2080 GND.n644 GND.n643 1.47702
R2081 GND.n748 GND.n747 1.47549
R2082 GND.n749 GND.n748 1.47549
R2083 GND.n874 GND.n6 1.38792
R2084 GND.n715 GND.n714 1.38792
R2085 GND.n736 GND.n735 1.38792
R2086 GND.n760 GND.n759 1.38792
R2087 GND.n498 GND.n497 1.38792
R2088 GND.n89 GND.n16 1.33756
R2089 GND GND.n509 1.32969
R2090 GND.n875 GND.n874 1.3005
R2091 GND.n876 GND.n875 1.3005
R2092 GND.n7 GND.n5 1.3005
R2093 GND.n13 GND.n5 1.3005
R2094 GND.n867 GND.n7 1.3005
R2095 GND.n867 GND.n14 1.3005
R2096 GND.n868 GND.n10 1.3005
R2097 GND.n869 GND.n868 1.3005
R2098 GND.n761 GND.n760 1.3005
R2099 GND.n761 GND.n24 1.3005
R2100 GND.n765 GND.n764 1.3005
R2101 GND.n764 GND.n763 1.3005
R2102 GND.n765 GND.n758 1.3005
R2103 GND.n762 GND.n758 1.3005
R2104 GND.n768 GND.n767 1.3005
R2105 GND.n769 GND.n768 1.3005
R2106 GND.n737 GND.n736 1.3005
R2107 GND.n738 GND.n737 1.3005
R2108 GND.n742 GND.n741 1.3005
R2109 GND.n741 GND.n740 1.3005
R2110 GND.n742 GND.n733 1.3005
R2111 GND.n739 GND.n733 1.3005
R2112 GND.n745 GND.n744 1.3005
R2113 GND.n746 GND.n745 1.3005
R2114 GND.n716 GND.n715 1.3005
R2115 GND.n717 GND.n716 1.3005
R2116 GND.n721 GND.n720 1.3005
R2117 GND.n720 GND.n719 1.3005
R2118 GND.n721 GND.n712 1.3005
R2119 GND.n718 GND.n712 1.3005
R2120 GND.n724 GND.n723 1.3005
R2121 GND.n725 GND.n724 1.3005
R2122 GND.n497 GND.n496 1.28485
R2123 GND.n331 GND.n267 1.28172
R2124 GND.n701 GND.n700 1.27181
R2125 GND.n129 GND.n128 1.27181
R2126 GND.n414 GND.n413 1.27181
R2127 GND.n380 GND.n379 1.27181
R2128 GND.n368 GND.n367 1.27181
R2129 GND.n625 GND.n624 1.27181
R2130 GND.n160 GND.n159 1.27181
R2131 GND.n181 GND.n180 1.27181
R2132 GND.n539 GND.n538 1.27181
R2133 GND.n846 GND.n782 1.2605
R2134 GND.n871 GND.t283 1.1975
R2135 GND.n848 GND.t289 1.1975
R2136 GND.n570 GND.n569 1.14617
R2137 GND.n16 GND.n11 1.13193
R2138 GND.n574 GND.n573 1.1255
R2139 GND.n572 GND.n343 1.1255
R2140 GND.n571 GND.n570 1.1255
R2141 GND.n511 GND.n510 1.1255
R2142 GND GND.n727 1.11264
R2143 GND GND.n750 1.11264
R2144 GND.n508 GND.n485 1.04767
R2145 GND.n849 GND.n848 1.03651
R2146 GND.n850 GND.n849 1.03651
R2147 GND.n871 GND.n870 1.03651
R2148 GND.n870 GND.n12 1.03651
R2149 GND.n501 GND.n500 1.0357
R2150 GND.n513 GND.n512 1.0355
R2151 GND.n727 GND.n726 0.986018
R2152 GND.n9 GND.n6 0.952242
R2153 GND.n714 GND.n713 0.952242
R2154 GND.n735 GND.n734 0.952242
R2155 GND.n766 GND.n759 0.952242
R2156 GND.n599 GND.n598 0.914196
R2157 GND.n597 GND.n204 0.914196
R2158 GND.n591 GND.n590 0.914196
R2159 GND.n589 GND.n332 0.914196
R2160 GND.n581 GND.n580 0.914196
R2161 GND.n568 GND.n347 0.873165
R2162 GND.n757 GND.n95 0.865283
R2163 GND.n864 GND.n863 0.865283
R2164 GND.t392 GND.n501 0.861176
R2165 GND.n8 GND 0.835786
R2166 GND.n519 GND.n472 0.820283
R2167 GND.n431 GND.n430 0.820283
R2168 GND.n695 GND.n694 0.820283
R2169 GND.n685 GND.n141 0.820283
R2170 GND.n461 GND.n460 0.820283
R2171 GND.n564 GND.n563 0.820283
R2172 GND.n660 GND.n172 0.820283
R2173 GND.n639 GND.n638 0.820283
R2174 GND.n610 GND.n195 0.820283
R2175 GND GND.n851 0.815794
R2176 GND.n521 GND 0.80463
R2177 GND.n433 GND 0.80463
R2178 GND.n697 GND 0.80463
R2179 GND.n687 GND 0.80463
R2180 GND GND.n458 0.80463
R2181 GND.n549 GND 0.80463
R2182 GND.n662 GND 0.80463
R2183 GND.n641 GND 0.80463
R2184 GND.n612 GND 0.80463
R2185 GND.n575 GND.n574 0.757167
R2186 GND.n878 GND.n3 0.739786
R2187 GND.n107 GND.n106 0.739786
R2188 GND.n728 GND.n106 0.739786
R2189 GND.n751 GND.n99 0.739786
R2190 GND.n852 GND.n25 0.739786
R2191 GND.n90 GND.n25 0.733786
R2192 GND.n99 GND.n94 0.7295
R2193 GND.n726 GND.n109 0.728875
R2194 GND.n478 GND.n477 0.5945
R2195 GND.n90 GND.n89 0.571576
R2196 GND.n568 GND.n567 0.513146
R2197 GND.n109 GND.n108 0.508217
R2198 GND.n747 GND.n100 0.508217
R2199 GND.n879 GND.n878 0.482643
R2200 GND.n730 GND.n729 0.453057
R2201 GND.n730 GND.n106 0.453057
R2202 GND.n753 GND.n752 0.453057
R2203 GND.n753 GND.n99 0.453057
R2204 GND.n854 GND.n853 0.453057
R2205 GND.n854 GND.n25 0.453057
R2206 GND.n877 GND.n2 0.453057
R2207 GND.n878 GND.n877 0.453057
R2208 GND.n35 GND.t682 0.45086
R2209 GND.n271 GND.t490 0.449392
R2210 GND.n483 GND.n472 0.44463
R2211 GND.n430 GND.n429 0.44463
R2212 GND.n694 GND.n693 0.44463
R2213 GND.n418 GND.n141 0.44463
R2214 GND.n462 GND.n461 0.44463
R2215 GND.n565 GND.n564 0.44463
R2216 GND.n185 GND.n172 0.44463
R2217 GND.n638 GND.n637 0.44463
R2218 GND.n543 GND.n195 0.44463
R2219 GND.n454 GND.n378 0.442674
R2220 GND.n691 GND.n690 0.442674
R2221 GND.n436 GND.n420 0.442674
R2222 GND.n524 GND.n464 0.442674
R2223 GND.n615 GND.n187 0.442674
R2224 GND.n665 GND.n164 0.442674
R2225 GND.n552 GND.n545 0.442674
R2226 GND.n522 GND.n521 0.440717
R2227 GND.n434 GND.n433 0.440717
R2228 GND.n698 GND.n697 0.440717
R2229 GND.n688 GND.n687 0.440717
R2230 GND.n458 GND.n457 0.440717
R2231 GND.n550 GND.n549 0.440717
R2232 GND.n663 GND.n662 0.440717
R2233 GND.n642 GND.n641 0.440717
R2234 GND.n613 GND.n612 0.440717
R2235 GND.n31 GND.t211 0.419969
R2236 GND.n276 GND.t46 0.419969
R2237 GND.n479 GND.n478 0.413222
R2238 GND.n277 GND.t634 0.405251
R2239 GND.t826 GND.n32 0.404944
R2240 GND GND.n0 0.388735
R2241 GND.n726 GND.t284 0.38142
R2242 GND GND.n3 0.366929
R2243 GND.n728 GND 0.366929
R2244 GND.n751 GND 0.366929
R2245 GND.n852 GND 0.366929
R2246 GND.n12 GND.n11 0.354071
R2247 GND.n12 GND.n8 0.353086
R2248 GND.t678 GND.t676 0.342917
R2249 GND.t486 GND.t484 0.342917
R2250 GND.n851 GND.n850 0.328877
R2251 GND.t578 GND.t118 0.31922
R2252 GND.t746 GND.n842 0.317858
R2253 GND.n499 GND.n498 0.313543
R2254 GND.n850 GND.n92 0.3125
R2255 GND.n513 GND.n475 0.309568
R2256 GND.n391 GND.n390 0.282568
R2257 GND.n677 GND.n146 0.282568
R2258 GND.n411 GND.n410 0.282568
R2259 GND.n364 GND.n363 0.282568
R2260 GND.n345 GND.n344 0.282568
R2261 GND.n619 GND.n175 0.282568
R2262 GND.n653 GND.n652 0.282568
R2263 GND.n556 GND.n534 0.282568
R2264 GND.t678 GND.n835 0.276268
R2265 GND.n750 GND.n749 0.257643
R2266 GND.n749 GND.n101 0.257643
R2267 GND.n872 GND.n871 0.250681
R2268 GND.n848 GND.n93 0.250681
R2269 GND.n326 GND.n325 0.234014
R2270 GND.n508 GND.n507 0.226587
R2271 GND.n507 GND.n506 0.226587
R2272 GND.n487 GND.n486 0.226587
R2273 GND.n505 GND.n487 0.226587
R2274 GND.n591 GND.n331 0.22322
R2275 GND.n50 GND.n49 0.222214
R2276 GND.n512 GND.n473 0.217167
R2277 GND.n491 GND.n473 0.217167
R2278 GND.n526 GND.n366 0.217167
R2279 GND.n366 GND.n357 0.217167
R2280 GND.n527 GND.n526 0.217167
R2281 GND.n528 GND.n527 0.217167
R2282 GND.n353 GND.n346 0.217167
R2283 GND.n532 GND.n353 0.217167
R2284 GND.n554 GND.n354 0.217167
R2285 GND.n533 GND.n354 0.217167
R2286 GND.n554 GND.n196 0.217167
R2287 GND.n334 GND.n196 0.217167
R2288 GND.n617 GND.n179 0.217167
R2289 GND.n605 GND.n179 0.217167
R2290 GND.n617 GND.n173 0.217167
R2291 GND.n603 GND.n173 0.217167
R2292 GND.n667 GND.n158 0.217167
R2293 GND.n158 GND.n151 0.217167
R2294 GND.n668 GND.n667 0.217167
R2295 GND.n669 GND.n668 0.217167
R2296 GND.n649 GND.n648 0.217167
R2297 GND.n648 GND.n647 0.217167
R2298 GND.n452 GND.n388 0.217167
R2299 GND.n404 GND.n388 0.217167
R2300 GND.n452 GND.n451 0.217167
R2301 GND.n451 GND.n450 0.217167
R2302 GND.n439 GND.n438 0.217167
R2303 GND.n440 GND.n439 0.217167
R2304 GND.n438 GND.n142 0.217167
R2305 GND.n442 GND.n142 0.217167
R2306 GND.n675 GND.n143 0.217167
R2307 GND.n671 GND.n143 0.217167
R2308 GND.n675 GND.n674 0.217167
R2309 GND.n674 GND.n673 0.217167
R2310 GND.n707 GND.n706 0.217167
R2311 GND.n708 GND.n707 0.217167
R2312 GND.n267 GND.n204 0.210953
R2313 GND.n840 GND.t345 0.209799
R2314 GND.t355 GND.n841 0.209572
R2315 GND.n84 GND.n83 0.20955
R2316 GND.t212 GND.n27 0.209063
R2317 GND.t100 GND.n213 0.209063
R2318 GND.t213 GND.t212 0.208994
R2319 GND.t214 GND.t213 0.208994
R2320 GND.t215 GND.t214 0.208994
R2321 GND.t216 GND.t215 0.208994
R2322 GND.t217 GND.t216 0.208994
R2323 GND.t218 GND.t217 0.208994
R2324 GND.t219 GND.t218 0.208994
R2325 GND.t220 GND.t219 0.208994
R2326 GND.t372 GND.t373 0.208994
R2327 GND.t371 GND.t372 0.208994
R2328 GND.t370 GND.t371 0.208994
R2329 GND.t369 GND.t370 0.208994
R2330 GND.t368 GND.t369 0.208994
R2331 GND.t367 GND.t368 0.208994
R2332 GND.t366 GND.t367 0.208994
R2333 GND.t365 GND.t366 0.208994
R2334 GND.t364 GND.t365 0.208994
R2335 GND.t101 GND.t100 0.208994
R2336 GND.t102 GND.t101 0.208994
R2337 GND.t103 GND.t102 0.208994
R2338 GND.t104 GND.t103 0.208994
R2339 GND.t105 GND.t104 0.208994
R2340 GND.t106 GND.t105 0.208994
R2341 GND.t107 GND.t106 0.208994
R2342 GND.t108 GND.t107 0.208994
R2343 GND.t46 GND.t47 0.208994
R2344 GND.t48 GND.t47 0.208994
R2345 GND.t49 GND.t48 0.208994
R2346 GND.t50 GND.t49 0.208994
R2347 GND.t51 GND.t50 0.208994
R2348 GND.t52 GND.t51 0.208994
R2349 GND.t53 GND.t52 0.208994
R2350 GND.t54 GND.t53 0.208994
R2351 GND.t55 GND.t54 0.208994
R2352 GND.n28 GND.t182 0.208852
R2353 GND.t192 GND.n29 0.208852
R2354 GND.n838 GND.t325 0.208852
R2355 GND.n839 GND.t335 0.208852
R2356 GND.t70 GND.n210 0.208852
R2357 GND.n211 GND.t80 0.208852
R2358 GND.n272 GND.t7 0.208852
R2359 GND.t27 GND.n274 0.208852
R2360 GND.n273 GND.t17 0.208852
R2361 GND.t193 GND.t192 0.208775
R2362 GND.t194 GND.t193 0.208775
R2363 GND.t195 GND.t194 0.208775
R2364 GND.t196 GND.t195 0.208775
R2365 GND.t197 GND.t196 0.208775
R2366 GND.t198 GND.t197 0.208775
R2367 GND.t199 GND.t198 0.208775
R2368 GND.t200 GND.t199 0.208775
R2369 GND.t189 GND.t190 0.208775
R2370 GND.t188 GND.t189 0.208775
R2371 GND.t187 GND.t188 0.208775
R2372 GND.t186 GND.t187 0.208775
R2373 GND.t185 GND.t186 0.208775
R2374 GND.t184 GND.t185 0.208775
R2375 GND.t183 GND.t184 0.208775
R2376 GND.t182 GND.t183 0.208775
R2377 GND.t345 GND.t346 0.208775
R2378 GND.t346 GND.t347 0.208775
R2379 GND.t347 GND.t348 0.208775
R2380 GND.t348 GND.t349 0.208775
R2381 GND.t349 GND.t350 0.208775
R2382 GND.t350 GND.t351 0.208775
R2383 GND.t351 GND.t352 0.208775
R2384 GND.t352 GND.t353 0.208775
R2385 GND.t332 GND.t333 0.208775
R2386 GND.t331 GND.t332 0.208775
R2387 GND.t330 GND.t331 0.208775
R2388 GND.t329 GND.t330 0.208775
R2389 GND.t328 GND.t329 0.208775
R2390 GND.t327 GND.t328 0.208775
R2391 GND.t326 GND.t327 0.208775
R2392 GND.t325 GND.t326 0.208775
R2393 GND.t336 GND.t335 0.208775
R2394 GND.t337 GND.t336 0.208775
R2395 GND.t338 GND.t337 0.208775
R2396 GND.t339 GND.t338 0.208775
R2397 GND.t340 GND.t339 0.208775
R2398 GND.t341 GND.t340 0.208775
R2399 GND.t342 GND.t341 0.208775
R2400 GND.t343 GND.t342 0.208775
R2401 GND.t80 GND.t81 0.208775
R2402 GND.t81 GND.t82 0.208775
R2403 GND.t82 GND.t83 0.208775
R2404 GND.t83 GND.t84 0.208775
R2405 GND.t84 GND.t85 0.208775
R2406 GND.t85 GND.t86 0.208775
R2407 GND.t86 GND.t87 0.208775
R2408 GND.t87 GND.t88 0.208775
R2409 GND.t78 GND.t77 0.208775
R2410 GND.t77 GND.t76 0.208775
R2411 GND.t76 GND.t75 0.208775
R2412 GND.t75 GND.t74 0.208775
R2413 GND.t74 GND.t73 0.208775
R2414 GND.t73 GND.t72 0.208775
R2415 GND.t72 GND.t71 0.208775
R2416 GND.t71 GND.t70 0.208775
R2417 GND.t28 GND.t27 0.208775
R2418 GND.t29 GND.t28 0.208775
R2419 GND.t30 GND.t29 0.208775
R2420 GND.t31 GND.t30 0.208775
R2421 GND.t32 GND.t31 0.208775
R2422 GND.t33 GND.t32 0.208775
R2423 GND.t34 GND.t33 0.208775
R2424 GND.t35 GND.t34 0.208775
R2425 GND.t17 GND.t18 0.208775
R2426 GND.t18 GND.t19 0.208775
R2427 GND.t19 GND.t20 0.208775
R2428 GND.t20 GND.t21 0.208775
R2429 GND.t21 GND.t22 0.208775
R2430 GND.t22 GND.t23 0.208775
R2431 GND.t23 GND.t24 0.208775
R2432 GND.t24 GND.t25 0.208775
R2433 GND.t14 GND.t15 0.208775
R2434 GND.t13 GND.t14 0.208775
R2435 GND.t12 GND.t13 0.208775
R2436 GND.t11 GND.t12 0.208775
R2437 GND.t10 GND.t11 0.208775
R2438 GND.t9 GND.t10 0.208775
R2439 GND.t8 GND.t9 0.208775
R2440 GND.t7 GND.t8 0.208775
R2441 GND.n30 GND.t202 0.208624
R2442 GND.n212 GND.t90 0.208624
R2443 GND.n275 GND.t37 0.208624
R2444 GND.t202 GND.t203 0.20854
R2445 GND.t203 GND.t204 0.20854
R2446 GND.t204 GND.t205 0.20854
R2447 GND.t205 GND.t206 0.20854
R2448 GND.t206 GND.t207 0.20854
R2449 GND.t207 GND.t208 0.20854
R2450 GND.t208 GND.t209 0.20854
R2451 GND.t209 GND.t210 0.20854
R2452 GND.t356 GND.t355 0.20854
R2453 GND.t357 GND.t356 0.20854
R2454 GND.t358 GND.t357 0.20854
R2455 GND.t359 GND.t358 0.20854
R2456 GND.t360 GND.t359 0.20854
R2457 GND.t361 GND.t360 0.20854
R2458 GND.t362 GND.t361 0.20854
R2459 GND.t363 GND.t362 0.20854
R2460 GND.t90 GND.t91 0.20854
R2461 GND.t91 GND.t92 0.20854
R2462 GND.t92 GND.t93 0.20854
R2463 GND.t93 GND.t94 0.20854
R2464 GND.t94 GND.t95 0.20854
R2465 GND.t95 GND.t96 0.20854
R2466 GND.t96 GND.t97 0.20854
R2467 GND.t97 GND.t98 0.20854
R2468 GND.t37 GND.t38 0.20854
R2469 GND.t38 GND.t39 0.20854
R2470 GND.t39 GND.t40 0.20854
R2471 GND.t40 GND.t41 0.20854
R2472 GND.t41 GND.t42 0.20854
R2473 GND.t42 GND.t43 0.20854
R2474 GND.t43 GND.t44 0.20854
R2475 GND.t44 GND.t45 0.20854
R2476 GND.n33 GND.t844 0.208392
R2477 GND.n269 GND.t652 0.208392
R2478 GND.n836 GND.t802 0.208369
R2479 GND.n208 GND.t610 0.208369
R2480 GND.t844 GND.t842 0.208285
R2481 GND.t842 GND.t840 0.208285
R2482 GND.t840 GND.t838 0.208285
R2483 GND.t838 GND.t836 0.208285
R2484 GND.t836 GND.t834 0.208285
R2485 GND.t834 GND.t832 0.208285
R2486 GND.t832 GND.t830 0.208285
R2487 GND.t830 GND.t828 0.208285
R2488 GND.t828 GND.t826 0.208285
R2489 GND.t818 GND.t820 0.208285
R2490 GND.t816 GND.t818 0.208285
R2491 GND.t814 GND.t816 0.208285
R2492 GND.t812 GND.t814 0.208285
R2493 GND.t810 GND.t812 0.208285
R2494 GND.t808 GND.t810 0.208285
R2495 GND.t806 GND.t808 0.208285
R2496 GND.t804 GND.t806 0.208285
R2497 GND.t802 GND.t804 0.208285
R2498 GND.t626 GND.t628 0.208285
R2499 GND.t624 GND.t626 0.208285
R2500 GND.t622 GND.t624 0.208285
R2501 GND.t620 GND.t622 0.208285
R2502 GND.t618 GND.t620 0.208285
R2503 GND.t616 GND.t618 0.208285
R2504 GND.t614 GND.t616 0.208285
R2505 GND.t612 GND.t614 0.208285
R2506 GND.t610 GND.t612 0.208285
R2507 GND.t652 GND.t650 0.208285
R2508 GND.t650 GND.t648 0.208285
R2509 GND.t648 GND.t646 0.208285
R2510 GND.t646 GND.t644 0.208285
R2511 GND.t644 GND.t642 0.208285
R2512 GND.t642 GND.t640 0.208285
R2513 GND.t640 GND.t638 0.208285
R2514 GND.t638 GND.t636 0.208285
R2515 GND.t636 GND.t634 0.208285
R2516 GND.t230 GND.t229 0.208009
R2517 GND.t229 GND.t228 0.208009
R2518 GND.t228 GND.t227 0.208009
R2519 GND.t227 GND.t226 0.208009
R2520 GND.t226 GND.t225 0.208009
R2521 GND.t225 GND.t224 0.208009
R2522 GND.t224 GND.t223 0.208009
R2523 GND.t223 GND.t222 0.208009
R2524 GND.t222 GND.t221 0.208009
R2525 GND.t118 GND.t117 0.208009
R2526 GND.t116 GND.t117 0.208009
R2527 GND.t115 GND.t116 0.208009
R2528 GND.t114 GND.t115 0.208009
R2529 GND.t113 GND.t114 0.208009
R2530 GND.t112 GND.t113 0.208009
R2531 GND.t111 GND.t112 0.208009
R2532 GND.t110 GND.t111 0.208009
R2533 GND.t109 GND.t110 0.208009
R2534 GND.n472 GND.n471 0.202864
R2535 GND.n520 GND.n469 0.202864
R2536 GND.n521 GND.n467 0.202864
R2537 GND.n430 GND.n427 0.202864
R2538 GND.n432 GND.n425 0.202864
R2539 GND.n433 GND.n423 0.202864
R2540 GND.n694 GND.n127 0.202864
R2541 GND.n696 GND.n125 0.202864
R2542 GND.n697 GND.n123 0.202864
R2543 GND.n141 GND.n140 0.202864
R2544 GND.n686 GND.n138 0.202864
R2545 GND.n687 GND.n136 0.202864
R2546 GND.n461 GND.n373 0.202864
R2547 GND.n459 GND.n375 0.202864
R2548 GND.n458 GND.n377 0.202864
R2549 GND.n564 GND.n349 0.202864
R2550 GND.n352 GND.n351 0.202864
R2551 GND.n549 GND.n548 0.202864
R2552 GND.n172 GND.n171 0.202864
R2553 GND.n661 GND.n169 0.202864
R2554 GND.n662 GND.n167 0.202864
R2555 GND.n638 GND.n635 0.202864
R2556 GND.n640 GND.n633 0.202864
R2557 GND.n641 GND.n631 0.202864
R2558 GND.n195 GND.n194 0.202864
R2559 GND.n611 GND.n192 0.202864
R2560 GND.n612 GND.n190 0.202864
R2561 GND.t210 GND.t220 0.202604
R2562 GND.t210 GND.t200 0.202604
R2563 GND.t200 GND.t190 0.202604
R2564 GND.t363 GND.t373 0.202604
R2565 GND.t343 GND.t353 0.202604
R2566 GND.t88 GND.t98 0.202604
R2567 GND.t88 GND.t78 0.202604
R2568 GND.t118 GND.t108 0.202604
R2569 GND.t45 GND.t55 0.202604
R2570 GND.t45 GND.t35 0.202604
R2571 GND.t35 GND.t25 0.202604
R2572 GND.t15 GND.t25 0.202604
R2573 GND.n837 GND.t704 0.202315
R2574 GND.n209 GND.t512 0.202315
R2575 GND.t794 GND.t822 0.201815
R2576 GND.t786 GND.t794 0.201815
R2577 GND.t778 GND.t786 0.201815
R2578 GND.t770 GND.t778 0.201815
R2579 GND.t762 GND.t770 0.201815
R2580 GND.t754 GND.t762 0.201815
R2581 GND.t746 GND.t754 0.201815
R2582 GND.t738 GND.t746 0.201815
R2583 GND.t730 GND.t738 0.201815
R2584 GND.t722 GND.t730 0.201815
R2585 GND.t714 GND.t722 0.201815
R2586 GND.t706 GND.t714 0.201815
R2587 GND.t678 GND.t706 0.201815
R2588 GND.t514 GND.t486 0.201815
R2589 GND.t522 GND.t514 0.201815
R2590 GND.t530 GND.t522 0.201815
R2591 GND.t538 GND.t530 0.201815
R2592 GND.t546 GND.t538 0.201815
R2593 GND.t554 GND.t546 0.201815
R2594 GND.t562 GND.t554 0.201815
R2595 GND.t570 GND.t562 0.201815
R2596 GND.t578 GND.t570 0.201815
R2597 GND.t586 GND.t578 0.201815
R2598 GND.t594 GND.t586 0.201815
R2599 GND.t602 GND.t594 0.201815
R2600 GND.t630 GND.t602 0.201815
R2601 GND.n842 GND.t363 0.201735
R2602 GND.t220 GND.t230 0.201604
R2603 GND.t333 GND.t343 0.201604
R2604 GND.t108 GND.t98 0.201604
R2605 GND.t784 GND.t792 0.201319
R2606 GND.t776 GND.t784 0.201319
R2607 GND.t768 GND.t776 0.201319
R2608 GND.t760 GND.t768 0.201319
R2609 GND.t752 GND.t760 0.201319
R2610 GND.t744 GND.t752 0.201319
R2611 GND.t736 GND.t744 0.201319
R2612 GND.t728 GND.t736 0.201319
R2613 GND.t720 GND.t728 0.201319
R2614 GND.t712 GND.t720 0.201319
R2615 GND.t704 GND.t712 0.201319
R2616 GND.t592 GND.t600 0.201319
R2617 GND.t584 GND.t592 0.201319
R2618 GND.t576 GND.t584 0.201319
R2619 GND.t568 GND.t576 0.201319
R2620 GND.t560 GND.t568 0.201319
R2621 GND.t552 GND.t560 0.201319
R2622 GND.t544 GND.t552 0.201319
R2623 GND.t536 GND.t544 0.201319
R2624 GND.t528 GND.t536 0.201319
R2625 GND.t520 GND.t528 0.201319
R2626 GND.t512 GND.t520 0.201319
R2627 GND.t344 GND.n839 0.20112
R2628 GND.t221 GND.n27 0.201113
R2629 GND.n213 GND.t109 0.201113
R2630 GND.n841 GND.t364 0.201099
R2631 GND.t354 GND.n840 0.201092
R2632 GND.t792 GND.n836 0.200409
R2633 GND.t600 GND.n208 0.200409
R2634 GND.t211 GND.n30 0.200128
R2635 GND.t99 GND.n212 0.200128
R2636 GND.t46 GND.n275 0.200128
R2637 GND.t334 GND.n838 0.200121
R2638 GND.t191 GND.n28 0.20012
R2639 GND.n29 GND.t201 0.20012
R2640 GND.n210 GND.t79 0.20012
R2641 GND.t89 GND.n211 0.20012
R2642 GND.t16 GND.n272 0.20012
R2643 GND.t26 GND.n273 0.20012
R2644 GND.n274 GND.t36 0.20012
R2645 GND.n292 GND.n291 0.19795
R2646 GND.t724 GND.t716 0.197884
R2647 GND.t532 GND.t524 0.197884
R2648 GND.t718 GND.t726 0.192308
R2649 GND.t526 GND.t534 0.192308
R2650 GND.n277 GND.t604 0.191295
R2651 GND.n35 GND.t708 0.191194
R2652 GND.t732 GND.t724 0.190894
R2653 GND.t540 GND.t532 0.190894
R2654 GND.t516 GND.n271 0.190778
R2655 GND.n32 GND.t796 0.189794
R2656 GND.t726 GND.t734 0.186289
R2657 GND.t534 GND.t542 0.186289
R2658 GND.n34 GND.t710 0.186186
R2659 GND.n270 GND.t518 0.186186
R2660 GND.t798 GND.n33 0.186142
R2661 GND.t606 GND.n269 0.186142
R2662 GND.t756 GND.t748 0.184505
R2663 GND.t564 GND.t556 0.184505
R2664 GND.n262 GND.n261 0.1845
R2665 GND.t796 GND.t788 0.184474
R2666 GND.t604 GND.t596 0.184474
R2667 GND.t772 GND.n31 0.184259
R2668 GND.t580 GND.n276 0.184259
R2669 GND.t658 GND.n837 0.182149
R2670 GND.t466 GND.n209 0.182149
R2671 GND.t682 GND.t684 0.181503
R2672 GND.t684 GND.t686 0.181503
R2673 GND.t686 GND.t688 0.181503
R2674 GND.t688 GND.t690 0.181503
R2675 GND.t690 GND.t692 0.181503
R2676 GND.t692 GND.t694 0.181503
R2677 GND.t694 GND.t696 0.181503
R2678 GND.t696 GND.t698 0.181503
R2679 GND.t698 GND.t700 0.181503
R2680 GND.t660 GND.t658 0.181503
R2681 GND.t662 GND.t660 0.181503
R2682 GND.t664 GND.t662 0.181503
R2683 GND.t666 GND.t664 0.181503
R2684 GND.t668 GND.t666 0.181503
R2685 GND.t670 GND.t668 0.181503
R2686 GND.t672 GND.t670 0.181503
R2687 GND.t674 GND.t672 0.181503
R2688 GND.t676 GND.t674 0.181503
R2689 GND.t468 GND.t466 0.181503
R2690 GND.t470 GND.t468 0.181503
R2691 GND.t472 GND.t470 0.181503
R2692 GND.t474 GND.t472 0.181503
R2693 GND.t476 GND.t474 0.181503
R2694 GND.t478 GND.t476 0.181503
R2695 GND.t480 GND.t478 0.181503
R2696 GND.t482 GND.t480 0.181503
R2697 GND.t484 GND.t482 0.181503
R2698 GND.t490 GND.t492 0.181503
R2699 GND.t492 GND.t494 0.181503
R2700 GND.t494 GND.t496 0.181503
R2701 GND.t496 GND.t498 0.181503
R2702 GND.t498 GND.t500 0.181503
R2703 GND.t500 GND.t502 0.181503
R2704 GND.t502 GND.t504 0.181503
R2705 GND.t504 GND.t506 0.181503
R2706 GND.t506 GND.t508 0.181503
R2707 GND.n706 GND.n120 0.1805
R2708 GND.n650 GND.n649 0.1805
R2709 GND.t766 GND.t774 0.179848
R2710 GND.t790 GND.t798 0.179848
R2711 GND.t574 GND.t582 0.179848
R2712 GND.t598 GND.t606 0.179848
R2713 GND.t750 GND.t758 0.179565
R2714 GND.t558 GND.t566 0.179565
R2715 GND.t780 GND.t772 0.178504
R2716 GND.t588 GND.t580 0.178504
R2717 GND.t788 GND.t780 0.178476
R2718 GND.t596 GND.t588 0.178476
R2719 GND.t764 GND.t756 0.178446
R2720 GND.t740 GND.t732 0.178446
R2721 GND.t716 GND.t708 0.178446
R2722 GND.t572 GND.t564 0.178446
R2723 GND.t548 GND.t540 0.178446
R2724 GND.t524 GND.t516 0.178446
R2725 GND.n471 GND.n470 0.177496
R2726 GND.n469 GND.n468 0.177496
R2727 GND.n467 GND.n466 0.177496
R2728 GND.n427 GND.n426 0.177496
R2729 GND.n425 GND.n424 0.177496
R2730 GND.n423 GND.n422 0.177496
R2731 GND.n127 GND.n126 0.177496
R2732 GND.n125 GND.n124 0.177496
R2733 GND.n123 GND.n122 0.177496
R2734 GND.n140 GND.n139 0.177496
R2735 GND.n138 GND.n137 0.177496
R2736 GND.n136 GND.n135 0.177496
R2737 GND.n373 GND.n372 0.177496
R2738 GND.n375 GND.n374 0.177496
R2739 GND.n377 GND.n376 0.177496
R2740 GND.n349 GND.n348 0.177496
R2741 GND.n351 GND.n350 0.177496
R2742 GND.n548 GND.n547 0.177496
R2743 GND.n171 GND.n170 0.177496
R2744 GND.n169 GND.n168 0.177496
R2745 GND.n167 GND.n166 0.177496
R2746 GND.n635 GND.n634 0.177496
R2747 GND.n633 GND.n632 0.177496
R2748 GND.n631 GND.n630 0.177496
R2749 GND.n194 GND.n193 0.177496
R2750 GND.n192 GND.n191 0.177496
R2751 GND.n190 GND.n189 0.177496
R2752 GND.n798 GND.n797 0.1765
R2753 GND.n486 GND.n1 0.175366
R2754 GND.t710 GND.t718 0.174077
R2755 GND.t734 GND.t742 0.174077
R2756 GND.t758 GND.t766 0.174077
R2757 GND.t518 GND.t526 0.174077
R2758 GND.t542 GND.t550 0.174077
R2759 GND.t566 GND.t574 0.174077
R2760 GND.t700 GND.n34 0.17399
R2761 GND.t508 GND.n270 0.17399
R2762 GND.t782 GND.t790 0.17381
R2763 GND.t590 GND.t598 0.17381
R2764 GND.t774 GND.t782 0.173514
R2765 GND.t582 GND.t590 0.173514
R2766 GND.t748 GND.t740 0.172858
R2767 GND.t556 GND.t548 0.172858
R2768 GND.t742 GND.t750 0.168134
R2769 GND.t550 GND.t558 0.168134
R2770 GND.n832 GND.n831 0.16575
R2771 GND.n228 GND.n227 0.16575
R2772 GND.n510 GND.n483 0.158344
R2773 GND.n509 GND.n484 0.153074
R2774 GND.n264 GND.n263 0.148363
R2775 GND.n703 GND.n702 0.140328
R2776 GND.n131 GND.n130 0.140328
R2777 GND.n416 GND.n415 0.140328
R2778 GND.n382 GND.n381 0.140328
R2779 GND.n370 GND.n369 0.140328
R2780 GND.n627 GND.n626 0.140328
R2781 GND.n162 GND.n161 0.140328
R2782 GND.n183 GND.n182 0.140328
R2783 GND.n541 GND.n540 0.140328
R2784 GND.n706 GND.n705 0.1355
R2785 GND.n649 GND.n644 0.1355
R2786 GND.n834 GND.n833 0.132477
R2787 GND.n72 GND.n71 0.126214
R2788 GND.n71 GND.n70 0.126214
R2789 GND.n70 GND.n69 0.126214
R2790 GND.n69 GND.n68 0.126214
R2791 GND.n68 GND.n67 0.126214
R2792 GND.n67 GND.n66 0.126214
R2793 GND.n66 GND.n65 0.126214
R2794 GND.n65 GND.n64 0.126214
R2795 GND.n64 GND.n63 0.126214
R2796 GND.n63 GND.n62 0.126214
R2797 GND.n62 GND.n61 0.126214
R2798 GND.n60 GND.n59 0.126214
R2799 GND.n59 GND.n58 0.126214
R2800 GND.n58 GND.n57 0.126214
R2801 GND.n57 GND.n56 0.126214
R2802 GND.n56 GND.n55 0.126214
R2803 GND.n55 GND.n54 0.126214
R2804 GND.n54 GND.n53 0.126214
R2805 GND.n53 GND.n52 0.126214
R2806 GND.n52 GND.n51 0.126214
R2807 GND.n51 GND.n50 0.126214
R2808 GND.n808 GND.n807 0.126214
R2809 GND.n807 GND.n806 0.126214
R2810 GND.n806 GND.n805 0.126214
R2811 GND.n805 GND.n804 0.126214
R2812 GND.n804 GND.n803 0.126214
R2813 GND.n803 GND.n802 0.126214
R2814 GND.n802 GND.n801 0.126214
R2815 GND.n801 GND.n800 0.126214
R2816 GND.n800 GND.n799 0.126214
R2817 GND.n799 GND.n798 0.126214
R2818 GND.n797 GND.n796 0.126214
R2819 GND.n796 GND.n795 0.126214
R2820 GND.n795 GND.n794 0.126214
R2821 GND.n794 GND.n793 0.126214
R2822 GND.n793 GND.n792 0.126214
R2823 GND.n792 GND.n791 0.126214
R2824 GND.n791 GND.n790 0.126214
R2825 GND.n790 GND.n789 0.126214
R2826 GND.n789 GND.n788 0.126214
R2827 GND.n788 GND.n787 0.126214
R2828 GND.n787 GND.n786 0.126214
R2829 GND.n786 GND.n785 0.126214
R2830 GND.n261 GND.n260 0.126214
R2831 GND.n260 GND.n259 0.126214
R2832 GND.n259 GND.n258 0.126214
R2833 GND.n258 GND.n257 0.126214
R2834 GND.n257 GND.n256 0.126214
R2835 GND.n256 GND.n255 0.126214
R2836 GND.n255 GND.n254 0.126214
R2837 GND.n254 GND.n253 0.126214
R2838 GND.n253 GND.n252 0.126214
R2839 GND.n252 GND.n251 0.126214
R2840 GND.n226 GND.n225 0.126214
R2841 GND.n225 GND.n224 0.126214
R2842 GND.n224 GND.n223 0.126214
R2843 GND.n223 GND.n222 0.126214
R2844 GND.n222 GND.n221 0.126214
R2845 GND.n221 GND.n220 0.126214
R2846 GND.n220 GND.n219 0.126214
R2847 GND.n219 GND.n218 0.126214
R2848 GND.n218 GND.n217 0.126214
R2849 GND.n217 GND.n216 0.126214
R2850 GND.n216 GND.n215 0.126214
R2851 GND.n325 GND.n324 0.126214
R2852 GND.n324 GND.n323 0.126214
R2853 GND.n323 GND.n322 0.126214
R2854 GND.n322 GND.n321 0.126214
R2855 GND.n321 GND.n320 0.126214
R2856 GND.n320 GND.n319 0.126214
R2857 GND.n319 GND.n318 0.126214
R2858 GND.n318 GND.n317 0.126214
R2859 GND.n317 GND.n316 0.126214
R2860 GND.n316 GND.n315 0.126214
R2861 GND.n314 GND.n313 0.126214
R2862 GND.n313 GND.n312 0.126214
R2863 GND.n312 GND.n311 0.126214
R2864 GND.n311 GND.n310 0.126214
R2865 GND.n310 GND.n309 0.126214
R2866 GND.n309 GND.n308 0.126214
R2867 GND.n308 GND.n307 0.126214
R2868 GND.n307 GND.n306 0.126214
R2869 GND.n306 GND.n305 0.126214
R2870 GND.n305 GND.n304 0.126214
R2871 GND.n304 GND.n303 0.126214
R2872 GND.n821 GND.n820 0.117919
R2873 GND.n820 GND.n819 0.117919
R2874 GND.n819 GND.n818 0.117919
R2875 GND.n818 GND.n817 0.117919
R2876 GND.n817 GND.n816 0.117919
R2877 GND.n816 GND.n815 0.117919
R2878 GND.n815 GND.n814 0.117919
R2879 GND.n814 GND.n813 0.117919
R2880 GND.n813 GND.n812 0.117919
R2881 GND.n812 GND.n811 0.117919
R2882 GND.n811 GND.n810 0.117919
R2883 GND.n810 GND.n809 0.117919
R2884 GND.n250 GND.n249 0.117919
R2885 GND.n249 GND.n248 0.117919
R2886 GND.n248 GND.n247 0.117919
R2887 GND.n247 GND.n246 0.117919
R2888 GND.n246 GND.n245 0.117919
R2889 GND.n245 GND.n244 0.117919
R2890 GND.n244 GND.n243 0.117919
R2891 GND.n243 GND.n242 0.117919
R2892 GND.n242 GND.n241 0.117919
R2893 GND.n241 GND.n240 0.117919
R2894 GND.n240 GND.n239 0.117919
R2895 GND.n239 GND.n238 0.117919
R2896 GND.n722 GND.n108 0.116691
R2897 GND.n743 GND.n100 0.116691
R2898 GND.n862 GND.n16 0.116094
R2899 GND.n83 GND.n82 0.1155
R2900 GND.n82 GND.n81 0.1155
R2901 GND.n81 GND.n80 0.1155
R2902 GND.n80 GND.n79 0.1155
R2903 GND.n79 GND.n78 0.1155
R2904 GND.n78 GND.n77 0.1155
R2905 GND.n77 GND.n76 0.1155
R2906 GND.n76 GND.n75 0.1155
R2907 GND.n75 GND.n74 0.1155
R2908 GND.n74 GND.n73 0.1155
R2909 GND.n49 GND.n48 0.1155
R2910 GND.n48 GND.n47 0.1155
R2911 GND.n47 GND.n46 0.1155
R2912 GND.n46 GND.n45 0.1155
R2913 GND.n45 GND.n44 0.1155
R2914 GND.n44 GND.n43 0.1155
R2915 GND.n43 GND.n42 0.1155
R2916 GND.n42 GND.n41 0.1155
R2917 GND.n41 GND.n40 0.1155
R2918 GND.n40 GND.n39 0.1155
R2919 GND.n39 GND.n38 0.1155
R2920 GND.n38 GND.n37 0.1155
R2921 GND.n831 GND.n830 0.1155
R2922 GND.n830 GND.n829 0.1155
R2923 GND.n829 GND.n828 0.1155
R2924 GND.n828 GND.n827 0.1155
R2925 GND.n827 GND.n826 0.1155
R2926 GND.n826 GND.n825 0.1155
R2927 GND.n825 GND.n824 0.1155
R2928 GND.n824 GND.n823 0.1155
R2929 GND.n823 GND.n822 0.1155
R2930 GND.n237 GND.n236 0.1155
R2931 GND.n236 GND.n235 0.1155
R2932 GND.n235 GND.n234 0.1155
R2933 GND.n234 GND.n233 0.1155
R2934 GND.n233 GND.n232 0.1155
R2935 GND.n232 GND.n231 0.1155
R2936 GND.n231 GND.n230 0.1155
R2937 GND.n230 GND.n229 0.1155
R2938 GND.n229 GND.n228 0.1155
R2939 GND.n302 GND.n301 0.1155
R2940 GND.n301 GND.n300 0.1155
R2941 GND.n300 GND.n299 0.1155
R2942 GND.n299 GND.n298 0.1155
R2943 GND.n298 GND.n297 0.1155
R2944 GND.n297 GND.n296 0.1155
R2945 GND.n296 GND.n295 0.1155
R2946 GND.n295 GND.n294 0.1155
R2947 GND.n294 GND.n293 0.1155
R2948 GND.n293 GND.n292 0.1155
R2949 GND.n291 GND.n290 0.1155
R2950 GND.n290 GND.n289 0.1155
R2951 GND.n289 GND.n288 0.1155
R2952 GND.n288 GND.n287 0.1155
R2953 GND.n287 GND.n286 0.1155
R2954 GND.n286 GND.n285 0.1155
R2955 GND.n285 GND.n284 0.1155
R2956 GND.n284 GND.n283 0.1155
R2957 GND.n283 GND.n282 0.1155
R2958 GND.n282 GND.n281 0.1155
R2959 GND.n281 GND.n280 0.1155
R2960 GND.n280 GND.n279 0.1155
R2961 GND.n782 GND.n781 0.113281
R2962 GND.n73 GND.n72 0.112414
R2963 GND.n61 GND.n60 0.112414
R2964 GND.n315 GND.n314 0.112414
R2965 GND.n303 GND.n302 0.112414
R2966 GND.n328 GND.n327 0.108363
R2967 GND.n832 GND.n785 0.106214
R2968 GND.n227 GND.n226 0.106214
R2969 GND.n262 GND.n215 0.106214
R2970 GND.n809 GND.n808 0.104019
R2971 GND.n251 GND.n250 0.104019
R2972 GND.n822 GND.n821 0.1017
R2973 GND.n238 GND.n237 0.1017
R2974 GND.n86 GND.n85 0.0974767
R2975 GND.n780 GND.n779 0.0960863
R2976 GND.n857 GND.n17 0.0960863
R2977 GND.n203 GND.n202 0.0960863
R2978 GND.n84 GND.n37 0.0955
R2979 GND.n326 GND.n279 0.0955
R2980 GND.n483 GND.n476 0.0931757
R2981 GND.n484 GND.t291 0.092694
R2982 GND.n499 GND.n485 0.0898576
R2983 GND.n500 GND.n496 0.0885435
R2984 GND.n690 GND.n133 0.0862328
R2985 GND.n437 GND.n436 0.0862328
R2986 GND.n454 GND.n453 0.0862328
R2987 GND.n666 GND.n665 0.0862328
R2988 GND.n616 GND.n615 0.0862328
R2989 GND.n553 GND.n552 0.0862328
R2990 GND.n847 GND.n846 0.0830857
R2991 GND.n873 GND.n7 0.0814227
R2992 GND.n722 GND.n721 0.0814227
R2993 GND.n743 GND.n742 0.0814227
R2994 GND.n765 GND.n91 0.0814227
R2995 GND.n569 GND.n568 0.0800904
R2996 GND.n599 GND.n203 0.077
R2997 GND.n598 GND.n597 0.077
R2998 GND.n590 GND.n589 0.077
R2999 GND.n581 GND.n332 0.077
R3000 GND.n515 GND.n514 0.0758623
R3001 GND.n516 GND.n515 0.0758623
R3002 GND.n519 GND.n518 0.0758623
R3003 GND.n518 GND.n517 0.0758623
R3004 GND.n559 GND.n558 0.0758623
R3005 GND.n560 GND.n559 0.0758623
R3006 GND.n563 GND.n562 0.0758623
R3007 GND.n562 GND.n561 0.0758623
R3008 GND.n606 GND.n174 0.0758623
R3009 GND.n607 GND.n606 0.0758623
R3010 GND.n610 GND.n609 0.0758623
R3011 GND.n609 GND.n608 0.0758623
R3012 GND.n656 GND.n655 0.0758623
R3013 GND.n657 GND.n656 0.0758623
R3014 GND.n660 GND.n659 0.0758623
R3015 GND.n659 GND.n658 0.0758623
R3016 GND.n651 GND.n152 0.0758623
R3017 GND.n646 GND.n152 0.0758623
R3018 GND.n639 GND.n153 0.0758623
R3019 GND.n645 GND.n153 0.0758623
R3020 GND.n389 GND.n358 0.0758623
R3021 GND.n402 GND.n358 0.0758623
R3022 GND.n460 GND.n359 0.0758623
R3023 GND.n400 GND.n359 0.0758623
R3024 GND.n394 GND.n393 0.0758623
R3025 GND.n406 GND.n394 0.0758623
R3026 GND.n431 GND.n395 0.0758623
R3027 GND.n447 GND.n395 0.0758623
R3028 GND.n680 GND.n679 0.0758623
R3029 GND.n681 GND.n680 0.0758623
R3030 GND.n685 GND.n684 0.0758623
R3031 GND.n684 GND.n683 0.0758623
R3032 GND.n145 GND.n112 0.0758623
R3033 GND.n113 GND.n112 0.0758623
R3034 GND.n695 GND.n116 0.0758623
R3035 GND.n116 GND.n115 0.0758623
R3036 GND.n781 GND.n95 0.0755682
R3037 GND.n781 GND.n780 0.0755682
R3038 GND.n862 GND.n17 0.0755682
R3039 GND.n863 GND.n862 0.0755682
R3040 GND.n480 GND.n477 0.064473
R3041 GND.n120 GND.n119 0.0631087
R3042 GND.n650 GND.n623 0.0631087
R3043 GND.n676 GND.n149 0.0591957
R3044 GND.n412 GND.n409 0.0591957
R3045 GND.n387 GND.n386 0.0591957
R3046 GND.n365 GND.n362 0.0591957
R3047 GND.n157 GND.n156 0.0591957
R3048 GND.n618 GND.n178 0.0591957
R3049 GND.n555 GND.n537 0.0591957
R3050 GND.n690 GND.n689 0.0552826
R3051 GND.n436 GND.n435 0.0552826
R3052 GND.n455 GND.n454 0.0552826
R3053 GND.n524 GND.n523 0.0552826
R3054 GND.n665 GND.n664 0.0552826
R3055 GND.n615 GND.n614 0.0552826
R3056 GND.n552 GND.n551 0.0552826
R3057 GND.n525 GND.n524 0.0536818
R3058 GND.n704 GND.n703 0.0525
R3059 GND.n132 GND.n131 0.0525
R3060 GND.n417 GND.n416 0.0525
R3061 GND.n383 GND.n382 0.0525
R3062 GND.n371 GND.n370 0.0525
R3063 GND.n628 GND.n627 0.0525
R3064 GND.n163 GND.n162 0.0525
R3065 GND.n184 GND.n183 0.0525
R3066 GND.n542 GND.n541 0.0525
R3067 GND.n573 GND.n345 0.0508133
R3068 GND.n503 GND.n484 0.0486481
R3069 GND.n504 GND.n503 0.0486481
R3070 GND.n502 GND.n0 0.0486481
R3071 GND.n502 GND.n4 0.0486481
R3072 GND.n480 GND.n479 0.0469118
R3073 GND.n510 GND 0.0461314
R3074 GND.n227 GND.t485 0.0436901
R3075 GND.n523 GND.n465 0.0433211
R3076 GND.n435 GND.n421 0.0433211
R3077 GND.n699 GND.n121 0.0433211
R3078 GND.n689 GND.n134 0.0433211
R3079 GND.n456 GND.n455 0.0433211
R3080 GND.n551 GND.n546 0.0433211
R3081 GND.n664 GND.n165 0.0433211
R3082 GND.n643 GND.n629 0.0433211
R3083 GND.n614 GND.n188 0.0433211
R3084 GND.n522 GND.n465 0.0429421
R3085 GND.n434 GND.n421 0.0429421
R3086 GND.n698 GND.n121 0.0429421
R3087 GND.n688 GND.n134 0.0429421
R3088 GND.n457 GND.n456 0.0429421
R3089 GND.n550 GND.n546 0.0429421
R3090 GND.n663 GND.n165 0.0429421
R3091 GND.n642 GND.n629 0.0429421
R3092 GND.n613 GND.n188 0.0429421
R3093 GND.n429 GND.n428 0.0428191
R3094 GND.n693 GND.n692 0.0428191
R3095 GND.n419 GND.n418 0.0428191
R3096 GND.n463 GND.n462 0.0428191
R3097 GND.n566 GND.n565 0.0428191
R3098 GND.n186 GND.n185 0.0428191
R3099 GND.n637 GND.n636 0.0428191
R3100 GND.n544 GND.n543 0.0428191
R3101 GND.n428 GND.n378 0.0424362
R3102 GND.n692 GND.n691 0.0424362
R3103 GND.n420 GND.n419 0.0424362
R3104 GND.n464 GND.n463 0.0424362
R3105 GND.n567 GND.n566 0.0424362
R3106 GND.n187 GND.n186 0.0424362
R3107 GND.n636 GND.n164 0.0424362
R3108 GND.n545 GND.n544 0.0424362
R3109 GND.n83 GND.t681 0.0376901
R3110 GND.n82 GND.t683 0.0376901
R3111 GND.n81 GND.t685 0.0376901
R3112 GND.n80 GND.t687 0.0376901
R3113 GND.n79 GND.t689 0.0376901
R3114 GND.n78 GND.t691 0.0376901
R3115 GND.n77 GND.t693 0.0376901
R3116 GND.n76 GND.t695 0.0376901
R3117 GND.n75 GND.t697 0.0376901
R3118 GND.n74 GND.t699 0.0376901
R3119 GND.n73 GND.t701 0.0376901
R3120 GND.n72 GND.t709 0.0376901
R3121 GND.n71 GND.t717 0.0376901
R3122 GND.n70 GND.t725 0.0376901
R3123 GND.n69 GND.t733 0.0376901
R3124 GND.n68 GND.t741 0.0376901
R3125 GND.n67 GND.t749 0.0376901
R3126 GND.n66 GND.t757 0.0376901
R3127 GND.n65 GND.t765 0.0376901
R3128 GND.n64 GND.t773 0.0376901
R3129 GND.n63 GND.t781 0.0376901
R3130 GND.n62 GND.t789 0.0376901
R3131 GND.n61 GND.t797 0.0376901
R3132 GND.n60 GND.t845 0.0376901
R3133 GND.n59 GND.t843 0.0376901
R3134 GND.n58 GND.t841 0.0376901
R3135 GND.n57 GND.t839 0.0376901
R3136 GND.n56 GND.t837 0.0376901
R3137 GND.n55 GND.t835 0.0376901
R3138 GND.n54 GND.t833 0.0376901
R3139 GND.n53 GND.t831 0.0376901
R3140 GND.n52 GND.t829 0.0376901
R3141 GND.n51 GND.t827 0.0376901
R3142 GND.n50 GND.t825 0.0376901
R3143 GND.n49 GND.t823 0.0376901
R3144 GND.n48 GND.t795 0.0376901
R3145 GND.n47 GND.t787 0.0376901
R3146 GND.n46 GND.t779 0.0376901
R3147 GND.n45 GND.t771 0.0376901
R3148 GND.n44 GND.t763 0.0376901
R3149 GND.n43 GND.t755 0.0376901
R3150 GND.n42 GND.t747 0.0376901
R3151 GND.n41 GND.t739 0.0376901
R3152 GND.n40 GND.t731 0.0376901
R3153 GND.n39 GND.t723 0.0376901
R3154 GND.n38 GND.t715 0.0376901
R3155 GND.n37 GND.t707 0.0376901
R3156 GND.n85 GND.t679 0.0376901
R3157 GND.n831 GND.t675 0.0376901
R3158 GND.n830 GND.t673 0.0376901
R3159 GND.n829 GND.t671 0.0376901
R3160 GND.n828 GND.t669 0.0376901
R3161 GND.n827 GND.t667 0.0376901
R3162 GND.n826 GND.t665 0.0376901
R3163 GND.n825 GND.t663 0.0376901
R3164 GND.n824 GND.t661 0.0376901
R3165 GND.n823 GND.t659 0.0376901
R3166 GND.n822 GND.t657 0.0376901
R3167 GND.n821 GND.t655 0.0376901
R3168 GND.n820 GND.t703 0.0376901
R3169 GND.n819 GND.t711 0.0376901
R3170 GND.n818 GND.t719 0.0376901
R3171 GND.n817 GND.t727 0.0376901
R3172 GND.n816 GND.t735 0.0376901
R3173 GND.n815 GND.t743 0.0376901
R3174 GND.n814 GND.t751 0.0376901
R3175 GND.n813 GND.t759 0.0376901
R3176 GND.n812 GND.t767 0.0376901
R3177 GND.n811 GND.t775 0.0376901
R3178 GND.n810 GND.t783 0.0376901
R3179 GND.n809 GND.t791 0.0376901
R3180 GND.n808 GND.t799 0.0376901
R3181 GND.n807 GND.t801 0.0376901
R3182 GND.n806 GND.t803 0.0376901
R3183 GND.n805 GND.t805 0.0376901
R3184 GND.n804 GND.t807 0.0376901
R3185 GND.n803 GND.t809 0.0376901
R3186 GND.n802 GND.t811 0.0376901
R3187 GND.n801 GND.t813 0.0376901
R3188 GND.n800 GND.t815 0.0376901
R3189 GND.n799 GND.t817 0.0376901
R3190 GND.n798 GND.t819 0.0376901
R3191 GND.n797 GND.t821 0.0376901
R3192 GND.n796 GND.t793 0.0376901
R3193 GND.n795 GND.t785 0.0376901
R3194 GND.n794 GND.t777 0.0376901
R3195 GND.n793 GND.t769 0.0376901
R3196 GND.n792 GND.t761 0.0376901
R3197 GND.n791 GND.t753 0.0376901
R3198 GND.n790 GND.t745 0.0376901
R3199 GND.n789 GND.t737 0.0376901
R3200 GND.n788 GND.t729 0.0376901
R3201 GND.n787 GND.t721 0.0376901
R3202 GND.n786 GND.t713 0.0376901
R3203 GND.n785 GND.t705 0.0376901
R3204 GND.n833 GND.t677 0.0376901
R3205 GND.n261 GND.t627 0.0376901
R3206 GND.n260 GND.t625 0.0376901
R3207 GND.n259 GND.t623 0.0376901
R3208 GND.n258 GND.t621 0.0376901
R3209 GND.n257 GND.t619 0.0376901
R3210 GND.n256 GND.t617 0.0376901
R3211 GND.n255 GND.t615 0.0376901
R3212 GND.n254 GND.t613 0.0376901
R3213 GND.n253 GND.t611 0.0376901
R3214 GND.n252 GND.t609 0.0376901
R3215 GND.n251 GND.t607 0.0376901
R3216 GND.n250 GND.t599 0.0376901
R3217 GND.n249 GND.t591 0.0376901
R3218 GND.n248 GND.t583 0.0376901
R3219 GND.n247 GND.t575 0.0376901
R3220 GND.n246 GND.t567 0.0376901
R3221 GND.n245 GND.t559 0.0376901
R3222 GND.n244 GND.t551 0.0376901
R3223 GND.n243 GND.t543 0.0376901
R3224 GND.n242 GND.t535 0.0376901
R3225 GND.n241 GND.t527 0.0376901
R3226 GND.n240 GND.t519 0.0376901
R3227 GND.n239 GND.t511 0.0376901
R3228 GND.n238 GND.t463 0.0376901
R3229 GND.n237 GND.t465 0.0376901
R3230 GND.n236 GND.t467 0.0376901
R3231 GND.n235 GND.t469 0.0376901
R3232 GND.n234 GND.t471 0.0376901
R3233 GND.n233 GND.t473 0.0376901
R3234 GND.n232 GND.t475 0.0376901
R3235 GND.n231 GND.t477 0.0376901
R3236 GND.n230 GND.t479 0.0376901
R3237 GND.n229 GND.t481 0.0376901
R3238 GND.n228 GND.t483 0.0376901
R3239 GND.n226 GND.t513 0.0376901
R3240 GND.n225 GND.t521 0.0376901
R3241 GND.n224 GND.t529 0.0376901
R3242 GND.n223 GND.t537 0.0376901
R3243 GND.n222 GND.t545 0.0376901
R3244 GND.n221 GND.t553 0.0376901
R3245 GND.n220 GND.t561 0.0376901
R3246 GND.n219 GND.t569 0.0376901
R3247 GND.n218 GND.t577 0.0376901
R3248 GND.n217 GND.t585 0.0376901
R3249 GND.n216 GND.t593 0.0376901
R3250 GND.n215 GND.t601 0.0376901
R3251 GND.n263 GND.t629 0.0376901
R3252 GND.n325 GND.t633 0.0376901
R3253 GND.n324 GND.t635 0.0376901
R3254 GND.n323 GND.t637 0.0376901
R3255 GND.n322 GND.t639 0.0376901
R3256 GND.n321 GND.t641 0.0376901
R3257 GND.n320 GND.t643 0.0376901
R3258 GND.n319 GND.t645 0.0376901
R3259 GND.n318 GND.t647 0.0376901
R3260 GND.n317 GND.t649 0.0376901
R3261 GND.n316 GND.t651 0.0376901
R3262 GND.n315 GND.t653 0.0376901
R3263 GND.n314 GND.t605 0.0376901
R3264 GND.n313 GND.t597 0.0376901
R3265 GND.n312 GND.t589 0.0376901
R3266 GND.n311 GND.t581 0.0376901
R3267 GND.n310 GND.t573 0.0376901
R3268 GND.n309 GND.t565 0.0376901
R3269 GND.n308 GND.t557 0.0376901
R3270 GND.n307 GND.t549 0.0376901
R3271 GND.n306 GND.t541 0.0376901
R3272 GND.n305 GND.t533 0.0376901
R3273 GND.n304 GND.t525 0.0376901
R3274 GND.n303 GND.t517 0.0376901
R3275 GND.n302 GND.t509 0.0376901
R3276 GND.n301 GND.t507 0.0376901
R3277 GND.n300 GND.t505 0.0376901
R3278 GND.n299 GND.t503 0.0376901
R3279 GND.n298 GND.t501 0.0376901
R3280 GND.n297 GND.t499 0.0376901
R3281 GND.n296 GND.t497 0.0376901
R3282 GND.n295 GND.t495 0.0376901
R3283 GND.n294 GND.t493 0.0376901
R3284 GND.n293 GND.t491 0.0376901
R3285 GND.n292 GND.t489 0.0376901
R3286 GND.n291 GND.t487 0.0376901
R3287 GND.n290 GND.t515 0.0376901
R3288 GND.n289 GND.t523 0.0376901
R3289 GND.n288 GND.t531 0.0376901
R3290 GND.n287 GND.t539 0.0376901
R3291 GND.n286 GND.t547 0.0376901
R3292 GND.n285 GND.t555 0.0376901
R3293 GND.n284 GND.t563 0.0376901
R3294 GND.n283 GND.t571 0.0376901
R3295 GND.n282 GND.t579 0.0376901
R3296 GND.n281 GND.t587 0.0376901
R3297 GND.n280 GND.t595 0.0376901
R3298 GND.n279 GND.t603 0.0376901
R3299 GND.n327 GND.t631 0.0376901
R3300 GND.n676 GND.n675 0.0365776
R3301 GND.n438 GND.n412 0.0365776
R3302 GND.n452 GND.n387 0.0365776
R3303 GND.n667 GND.n157 0.0365776
R3304 GND.n618 GND.n617 0.0365776
R3305 GND.n555 GND.n554 0.0365776
R3306 GND.n483 GND.n482 0.0353361
R3307 GND.n756 GND.n96 0.0351722
R3308 GND.n861 GND.n18 0.0351722
R3309 GND.n9 GND.n7 0.0333326
R3310 GND.n721 GND.n713 0.0333326
R3311 GND.n742 GND.n734 0.0333326
R3312 GND.n766 GND.n765 0.0333326
R3313 GND.n678 GND.n677 0.0330862
R3314 GND.n411 GND.n144 0.0330862
R3315 GND.n392 GND.n391 0.0330862
R3316 GND.n654 GND.n653 0.0330862
R3317 GND.n620 GND.n619 0.0330862
R3318 GND.n557 GND.n556 0.0330862
R3319 GND.n486 GND.n484 0.0309813
R3320 GND.n873 GND.n872 0.0284634
R3321 GND.n93 GND.n91 0.0284634
R3322 GND.n576 GND.n341 0.0258636
R3323 GND.n526 GND.n365 0.0228797
R3324 GND.n480 GND.n476 0.0221486
R3325 GND.t392 GND.n495 0.0219245
R3326 GND.n677 GND.n676 0.0218362
R3327 GND.n412 GND.n411 0.0218362
R3328 GND.n391 GND.n387 0.0218362
R3329 GND.n653 GND.n157 0.0218362
R3330 GND.n619 GND.n618 0.0218362
R3331 GND.n556 GND.n555 0.0218362
R3332 GND.n574 GND.n343 0.0211667
R3333 GND.n570 GND.n343 0.0211667
R3334 GND.n364 GND.n347 0.0207139
R3335 GND.n119 GND.n117 0.0203261
R3336 GND.n149 GND.n147 0.0203261
R3337 GND.n409 GND.n407 0.0203261
R3338 GND.n386 GND.n384 0.0203261
R3339 GND.n362 GND.n360 0.0203261
R3340 GND.n623 GND.n621 0.0203261
R3341 GND.n156 GND.n154 0.0203261
R3342 GND.n178 GND.n176 0.0203261
R3343 GND.n537 GND.n535 0.0203261
R3344 GND.n482 GND.n481 0.0192059
R3345 GND.n847 GND.n92 0.0185
R3346 GND.n118 GND.n117 0.0185
R3347 GND.n148 GND.n147 0.0185
R3348 GND.n408 GND.n407 0.0185
R3349 GND.n385 GND.n384 0.0185
R3350 GND.n361 GND.n360 0.0185
R3351 GND.n622 GND.n621 0.0185
R3352 GND.n155 GND.n154 0.0185
R3353 GND.n177 GND.n176 0.0185
R3354 GND.n536 GND.n535 0.0185
R3355 GND GND.n520 0.0181087
R3356 GND GND.n432 0.0181087
R3357 GND GND.n696 0.0181087
R3358 GND GND.n686 0.0181087
R3359 GND.n459 GND 0.0181087
R3360 GND GND.n352 0.0181087
R3361 GND GND.n661 0.0181087
R3362 GND GND.n640 0.0181087
R3363 GND GND.n611 0.0181087
R3364 GND.n481 GND.n480 0.0162059
R3365 GND.n573 GND.n572 0.0139458
R3366 GND.n572 GND.n571 0.0139458
R3367 GND.n365 GND.n364 0.0137353
R3368 GND.n341 GND.n340 0.0136462
R3369 GND.n579 GND.n337 0.0136462
R3370 GND.n340 GND.n339 0.0136462
R3371 GND.n339 GND.n337 0.0136462
R3372 GND.n36 GND.t680 0.0119192
R3373 GND.n278 GND.t632 0.01154
R3374 GND.n675 GND.n133 0.0113621
R3375 GND.n438 GND.n437 0.0113621
R3376 GND.n453 GND.n452 0.0113621
R3377 GND.n667 GND.n666 0.0113621
R3378 GND.n617 GND.n616 0.0113621
R3379 GND.n554 GND.n553 0.0113621
R3380 GND.n575 GND.n342 0.0113097
R3381 GND.n342 GND.n338 0.0113097
R3382 GND.n578 GND.n338 0.0113097
R3383 GND.n578 GND.n577 0.0113097
R3384 GND.n569 GND.n346 0.0109096
R3385 GND.n214 GND.t630 0.0103457
R3386 GND.n843 GND.t678 0.0102525
R3387 GND.n329 GND.n278 0.00906064
R3388 GND.n36 GND.n26 0.00893922
R3389 GND.n265 GND.n214 0.00810376
R3390 GND.n784 GND.n783 0.00742308
R3391 GND.n748 GND.t286 0.00735985
R3392 GND.n526 GND.n525 0.00723797
R3393 GND.n833 GND.n832 0.0065
R3394 GND.n263 GND.n262 0.0065
R3395 GND.n870 GND.t282 0.00399747
R3396 GND.n849 GND.t288 0.00399747
R3397 GND.n571 GND.n346 0.00353614
R3398 GND.n702 GND.n701 0.00300333
R3399 GND.n130 GND.n129 0.00300333
R3400 GND.n415 GND.n414 0.00300333
R3401 GND.n381 GND.n380 0.00300333
R3402 GND.n369 GND.n368 0.00300333
R3403 GND.n626 GND.n625 0.00300333
R3404 GND.n161 GND.n160 0.00300333
R3405 GND.n182 GND.n181 0.00300333
R3406 GND.n540 GND.n539 0.00300333
R3407 GND.n85 GND.n84 0.0027
R3408 GND.n327 GND.n326 0.0027
R3409 GND.n520 GND.n519 0.00245652
R3410 GND.n432 GND.n431 0.00245652
R3411 GND.n696 GND.n695 0.00245652
R3412 GND.n686 GND.n685 0.00245652
R3413 GND.n460 GND.n459 0.00245652
R3414 GND.n563 GND.n352 0.00245652
R3415 GND.n661 GND.n660 0.00245652
R3416 GND.n640 GND.n639 0.00245652
R3417 GND.n611 GND.n610 0.00245652
R3418 GND.t680 GND.n35 0.00197895
R3419 GND.t632 GND.n277 0.00190894
R3420 GND.n877 GND.t414 0.00180838
R3421 GND.t413 GND.n854 0.00180838
R3422 GND.t412 GND.n753 0.00180838
R3423 GND.t411 GND.n730 0.00180838
R3424 GND.n31 GND.t764 0.00149991
R3425 GND.n276 GND.t572 0.00149991
R3426 GND.n271 GND.t488 0.00147517
R3427 GND.n32 GND.t824 0.00144492
R3428 GND.n837 GND.t656 0.00144304
R3429 GND.n209 GND.t464 0.00144304
R3430 GND.n840 GND.t344 0.0013675
R3431 GND.n841 GND.t354 0.00136251
R3432 GND.n278 GND.n268 0.00134795
R3433 GND.t211 GND.n27 0.00133878
R3434 GND.n213 GND.t99 0.00133878
R3435 GND.n87 GND.n36 0.00133669
R3436 GND.n29 GND.t191 0.00133391
R3437 GND.n28 GND.t181 0.00133391
R3438 GND.n839 GND.t334 0.00133391
R3439 GND.n838 GND.t324 0.00133391
R3440 GND.n211 GND.t79 0.00133391
R3441 GND.n210 GND.t69 0.00133391
R3442 GND.n274 GND.t26 0.00133391
R3443 GND.n273 GND.t16 0.00133391
R3444 GND.n272 GND.t6 0.00133391
R3445 GND.n836 GND.t800 0.00132935
R3446 GND.n208 GND.t608 0.00132935
R3447 GND.n30 GND.t201 0.00132897
R3448 GND.n212 GND.t89 0.00132897
R3449 GND.n275 GND.t36 0.00132897
R3450 GND.n33 GND.t846 0.00130564
R3451 GND.n269 GND.t654 0.00130564
R3452 GND.n842 GND.t353 0.00128432
R3453 GND.n214 GND.n207 0.00126998
R3454 GND.n34 GND.t702 0.00125841
R3455 GND.n270 GND.t510 0.00125841
R3456 GND.n781 GND.n96 0.00109001
R3457 GND.n862 GND.n861 0.00109001
R3458 GND.n835 GND.n783 0.000961538
R3459 GND.n843 GND.n784 0.000961538
C442 VbiasN GND 38.40704f
C443 VbiasP GND 26.1566f
C444 VDD05 GND 55.15748f
C445 Cap2 GND 14.80455f
C446 Cap1 GND 13.17576f
C447 Cap0 GND 14.45452f
C448 Vout GND 9.94995f
C449 VDD GND 0.91108p
C450 a_32752_n13750# GND 35.7917f **FLOATING
C451 a_31752_n13750# GND 37.9012f **FLOATING
C452 a_30752_n13750# GND 24.759f **FLOATING
C453 a_21752_n13750# GND 50.889f **FLOATING
C454 a_20752_n13750# GND 22.5261f **FLOATING
C455 a_19752_n13750# GND 13.4091f **FLOATING
C456 a_45120_n9520# GND 0.66108f **FLOATING
C457 a_34920_n11090# GND 0.66217f **FLOATING
C458 a_24250_n11090# GND 0.66217f **FLOATING
C459 a_13570_n11110# GND 0.66346f **FLOATING
C460 a_2910_n11110# GND 0.66346f **FLOATING
C461 B04_OTA_bias_ratio_5_0.Vbias1 GND 9.86317f **FLOATING
C462 a_45272_n4544# GND 1.61102f **FLOATING
C463 a_45272_n4132# GND 1.16291f **FLOATING
C464 B04_OTA_bias_ratio_5_0.Vbias2 GND 16.0492f **FLOATING
C465 a_33892_n4544# GND 1.60599f **FLOATING
C466 a_33892_n4132# GND 1.25143f **FLOATING
C467 a_23222_n4544# GND 1.53391f **FLOATING
C468 a_23222_n4132# GND 1.25143f **FLOATING
C469 a_12552_n4544# GND 1.61152f **FLOATING
C470 a_12552_n4132# GND 1.25172f **FLOATING
C471 a_1882_n4544# GND 1.61418f **FLOATING
C472 a_1882_n4132# GND 1.2605f **FLOATING
C473 a_44984_n4544# GND 6.81857f **FLOATING
C474 a_44374_n2762# GND 6.10676f **FLOATING
C475 a_45734_n2430# GND 3.6182f **FLOATING
C476 a_44374_n2430# GND 3.19053f **FLOATING
C477 B04_OTA_bias_ratio_5_0.Vbias3 GND 12.494f **FLOATING
C478 B04_OTA_bias_ratio_5_0.Vbias0 GND 8.06183f **FLOATING
C479 a_33604_n4544# GND 6.70102f **FLOATING
C480 a_32994_n2762# GND 6.09987f **FLOATING
C481 a_34354_n2430# GND 3.64783f **FLOATING
C482 a_32994_n2430# GND 3.26823f **FLOATING
C483 B04_OTA_4.Vin- GND 0.19965p **FLOATING
C484 a_22934_n4544# GND 6.70102f **FLOATING
C485 a_22324_n2762# GND 6.0898f **FLOATING
C486 a_23684_n2430# GND 3.64723f **FLOATING
C487 a_22324_n2430# GND 3.00118f **FLOATING
C488 a_12264_n4544# GND 6.77703f **FLOATING
C489 a_11654_n2762# GND 6.15599f **FLOATING
C490 a_13014_n2430# GND 3.71095f **FLOATING
C491 a_11654_n2430# GND 3.31483f **FLOATING
C492 B04_OTA_6.Vin- GND 0.21274p **FLOATING
C493 a_1594_n4544# GND 6.77637f **FLOATING
C494 a_984_n2762# GND 6.16817f **FLOATING
C495 a_2344_n2430# GND 3.7132f **FLOATING
C496 a_984_n2430# GND 3.30824f **FLOATING
C497 B04_OTA_4.Vbias1 GND 15.1498f **FLOATING
C498 a_33892_1516# GND 1.5103f **FLOATING
C499 a_33892_1928# GND 1.14104f **FLOATING
C500 B04_OTA_4.Vbias2 GND 25.729f **FLOATING
C501 B04_OTA_bias_ratio_04_0.Vbias1 GND 15.0113f **FLOATING
C502 a_23222_1516# GND 1.50066f **FLOATING
C503 a_23222_1928# GND 1.0467f **FLOATING
C504 B04_OTA_bias_ratio_04_0.Vbias2 GND 25.5767f **FLOATING
C505 B04_OTA_bias_ratio_025_1.Vbias1 GND 15.1677f **FLOATING
C506 a_12552_1516# GND 1.50755f **FLOATING
C507 a_12552_1928# GND 1.046f **FLOATING
C508 B04_OTA_bias_ratio_025_1.Vbias2 GND 25.7941f **FLOATING
C509 B04_OTA_bias_ratio_025_0.Vbias1 GND 15.1457f **FLOATING
C510 a_1882_1516# GND 1.49069f **FLOATING
C511 a_1882_1928# GND 1.02378f **FLOATING
C512 B04_OTA_bias_ratio_025_0.Vbias2 GND 25.8965f **FLOATING
C513 a_33604_1516# GND 6.67061f **FLOATING
C514 a_32994_3298# GND 6.00782f **FLOATING
C515 a_34354_3630# GND 3.43284f **FLOATING
C516 a_32994_3630# GND 3.04624f **FLOATING
C517 B04_OTA_4.Vbias3 GND 8.73732f **FLOATING
C518 a_36966_3298# GND 0.59331f **FLOATING
C519 B04_OTA_4.Vbias0 GND 5.73941f **FLOATING
C520 B04_OTA_3.Vin- GND 0.1969p **FLOATING
C521 a_22934_1516# GND 6.66656f **FLOATING
C522 a_22324_3298# GND 5.99894f **FLOATING
C523 a_23684_3630# GND 3.37803f **FLOATING
C524 a_22324_3630# GND 2.95969f **FLOATING
C525 B04_OTA_bias_ratio_04_0.Vbias3 GND 8.23897f **FLOATING
C526 a_26296_3298# GND 0.59722f **FLOATING
C527 B04_OTA_bias_ratio_04_0.Vbias0 GND 5.71085f **FLOATING
C528 a_12264_1516# GND 6.74263f **FLOATING
C529 a_11654_3298# GND 6.05752f **FLOATING
C530 a_13014_3630# GND 3.44115f **FLOATING
C531 a_11654_3630# GND 2.99789f **FLOATING
C532 B04_OTA_bias_ratio_025_1.Vbias3 GND 8.30215f **FLOATING
C533 a_15626_3298# GND 0.60024f **FLOATING
C534 B04_OTA_bias_ratio_025_1.Vbias0 GND 6.67015f **FLOATING
C535 B04_OTA_7.Vin+ GND 0.23368p **FLOATING
C536 a_1594_1516# GND 6.73388f **FLOATING
C537 a_984_3298# GND 6.07085f **FLOATING
C538 a_2344_3630# GND 3.40083f **FLOATING
C539 a_984_3630# GND 2.95742f **FLOATING
C540 B04_OTA_bias_ratio_025_0.Vbias3 GND 8.79867f **FLOATING
C541 a_4956_3298# GND 0.59881f **FLOATING
C542 B04_OTA_bias_ratio_025_0.Vbias0 GND 6.64127f **FLOATING
C543 a_32752_6250# GND 35.8938f **FLOATING
C544 a_31752_6250# GND 37.5302f **FLOATING
C545 a_30752_6250# GND 25.1571f **FLOATING
C546 a_21752_6250# GND 50.6719f **FLOATING
C547 a_20752_6250# GND 22.7061f **FLOATING
C548 a_19752_6250# GND 13.3502f **FLOATING
C549 B04_OTA_8.Vin- GND 21.2825f **FLOATING
C550 VDD.n2 GND 0.66083f **FLOATING
C551 VDD.n3 GND 1.16914f **FLOATING
C552 VDD.n4 GND 0.54039f **FLOATING
C553 VDD.n5 GND 0.53954f **FLOATING
C554 VDD.n6 GND 0.62723f **FLOATING
C555 VDD.n31 GND 0.54039f **FLOATING
C556 VDD.n32 GND 0.53954f **FLOATING
C557 VDD.n33 GND 0.62723f **FLOATING
C558 VDD.n37 GND 0.66083f **FLOATING
C559 VDD.n61 GND 0.54039f **FLOATING
C560 VDD.n62 GND 0.53954f **FLOATING
C561 VDD.n63 GND 0.62723f **FLOATING
C562 VDD.n67 GND 0.66083f **FLOATING
C563 VDD.n91 GND 0.54039f **FLOATING
C564 VDD.n92 GND 0.53954f **FLOATING
C565 VDD.n93 GND 0.62723f **FLOATING
C566 VDD.n97 GND 0.66083f **FLOATING
C567 VDD.n103 GND 0.54058f **FLOATING
C568 VDD.t101 GND 0.75871f **FLOATING
C569 VDD.n122 GND 0.82868f **FLOATING
C570 VDD.t389 GND 0.75871f **FLOATING
C571 VDD.t100 GND 0.75871f **FLOATING
C572 VDD.n125 GND 0.82868f **FLOATING
C573 VDD.t147 GND 0.75871f **FLOATING
C574 VDD.t99 GND 0.75871f **FLOATING
C575 VDD.n127 GND 0.82868f **FLOATING
C576 VDD.t138 GND 0.75866f **FLOATING
C577 VDD.t113 GND 0.75871f **FLOATING
C578 VDD.n129 GND 0.82868f **FLOATING
C579 VDD.t88 GND 0.75871f **FLOATING
C580 VDD.t112 GND 0.75871f **FLOATING
C581 VDD.n130 GND 0.82868f **FLOATING
C582 VDD.t190 GND 0.76315f **FLOATING
C583 VDD.t390 GND 1.38112f **FLOATING
C584 VDD.n131 GND 1.4935f **FLOATING
C585 VDD.t180 GND 0.75367f **FLOATING
C586 VDD.n133 GND 0.65623f **FLOATING
C587 VDD.n134 GND 1.60842f **FLOATING
C588 VDD.n135 GND 0.54824f **FLOATING
C589 VDD.n136 GND 1.04636f **FLOATING
C590 VDD.n137 GND 1.3516f **FLOATING
C591 VDD.t164 GND 2.88032f **FLOATING
C592 VDD.n138 GND 1.27557f **FLOATING
C593 VDD.n139 GND 2.93346f **FLOATING
C594 VDD.n141 GND 1.32785f **FLOATING
C595 VDD.t391 GND 1.38112f **FLOATING
C596 VDD.n142 GND 1.4935f **FLOATING
C597 VDD.t102 GND 0.75367f **FLOATING
C598 VDD.n144 GND 0.65623f **FLOATING
C599 VDD.n146 GND 0.54824f **FLOATING
C600 VDD.n147 GND 0.89092f **FLOATING
C601 VDD.n149 GND 0.70053f **FLOATING
C602 VDD.n151 GND 1.41066f **FLOATING
C603 VDD.t392 GND 1.38112f **FLOATING
C604 VDD.n152 GND 1.4935f **FLOATING
C605 VDD.t97 GND 0.75367f **FLOATING
C606 VDD.n154 GND 0.65623f **FLOATING
C607 VDD.n156 GND 0.54824f **FLOATING
C608 VDD.n157 GND 0.89092f **FLOATING
C609 VDD.n159 GND 0.70053f **FLOATING
C610 VDD.n161 GND 1.4143f **FLOATING
C611 VDD.t393 GND 1.38112f **FLOATING
C612 VDD.n162 GND 1.4935f **FLOATING
C613 VDD.t383 GND 0.75367f **FLOATING
C614 VDD.n164 GND 0.65623f **FLOATING
C615 VDD.n166 GND 0.54824f **FLOATING
C616 VDD.n167 GND 0.89092f **FLOATING
C617 VDD.n168 GND 0.65881f **FLOATING
C618 VDD.n170 GND 1.38472f **FLOATING
C619 VDD.t394 GND 1.38112f **FLOATING
C620 VDD.n171 GND 1.4935f **FLOATING
C621 VDD.t174 GND 0.75367f **FLOATING
C622 VDD.n173 GND 0.65623f **FLOATING
C623 VDD.n175 GND 0.54824f **FLOATING
C624 VDD.n176 GND 0.89092f **FLOATING
C625 VDD.n177 GND 0.65881f **FLOATING
C626 VDD.n178 GND 0.62032f **FLOATING
C627 VDD.n179 GND 1.90287f **FLOATING
C628 VDD.n180 GND 0.54039f **FLOATING
C629 VDD.n181 GND 0.53954f **FLOATING
C630 VDD.n191 GND 1.57052f **FLOATING
C631 VDD.n192 GND 1.18814f **FLOATING
C632 VDD.t299 GND 1.843f **FLOATING
C633 VDD.t146 GND 2.30123f **FLOATING
C634 VDD.t145 GND 2.30123f **FLOATING
C635 VDD.t144 GND 2.30123f **FLOATING
C636 VDD.t143 GND 1.74127f **FLOATING
C637 VDD.t302 GND 0.8657f **FLOATING
C638 VDD.t64 GND 0.82625f **FLOATING
C639 VDD.t65 GND 0.66626f **FLOATING
C640 VDD.t67 GND 0.7342f **FLOATING
C641 VDD.t68 GND 0.74735f **FLOATING
C642 VDD.t70 GND 0.66626f **FLOATING
C643 VDD.t71 GND 0.82406f **FLOATING
C644 VDD.t305 GND 1.35663f **FLOATING
C645 VDD.t296 GND 1.29417f **FLOATING
C646 VDD.n195 GND 0.66083f **FLOATING
C647 VDD.n198 GND 0.54039f **FLOATING
C648 VDD.n199 GND 0.53954f **FLOATING
C649 VDD.n209 GND 1.57052f **FLOATING
C650 VDD.n210 GND 1.18814f **FLOATING
C651 VDD.t339 GND 1.843f **FLOATING
C652 VDD.t14 GND 2.30123f **FLOATING
C653 VDD.t12 GND 2.30123f **FLOATING
C654 VDD.t8 GND 2.30123f **FLOATING
C655 VDD.t10 GND 1.74127f **FLOATING
C656 VDD.t342 GND 0.8657f **FLOATING
C657 VDD.t80 GND 0.82625f **FLOATING
C658 VDD.t81 GND 0.66626f **FLOATING
C659 VDD.t83 GND 0.7342f **FLOATING
C660 VDD.t84 GND 0.74735f **FLOATING
C661 VDD.t86 GND 0.66626f **FLOATING
C662 VDD.t87 GND 0.82406f **FLOATING
C663 VDD.t345 GND 1.35663f **FLOATING
C664 VDD.t336 GND 1.29417f **FLOATING
C665 VDD.n213 GND 0.66083f **FLOATING
C666 VDD.n217 GND 0.55333f **FLOATING
C667 VDD.n222 GND 0.62723f **FLOATING
C668 VDD.n228 GND 0.66083f **FLOATING
C669 VDD.n234 GND 0.62723f **FLOATING
C670 VDD.n236 GND 0.54039f **FLOATING
C671 VDD.n237 GND 0.55997f **FLOATING
C672 VDD.n238 GND 0.72215f **FLOATING
C673 VDD.n239 GND 0.53954f **FLOATING
C674 VDD.n265 GND 1.57052f **FLOATING
C675 VDD.t319 GND 1.843f **FLOATING
C676 VDD.t137 GND 2.30123f **FLOATING
C677 VDD.t136 GND 2.30123f **FLOATING
C678 VDD.t135 GND 2.30123f **FLOATING
C679 VDD.t134 GND 1.74127f **FLOATING
C680 VDD.n266 GND 0.72215f **FLOATING
C681 VDD.n267 GND 0.55997f **FLOATING
C682 VDD.t316 GND 1.29417f **FLOATING
C683 VDD.t325 GND 1.35663f **FLOATING
C684 VDD.t75 GND 0.82406f **FLOATING
C685 VDD.t74 GND 0.66626f **FLOATING
C686 VDD.t72 GND 0.74735f **FLOATING
C687 VDD.t79 GND 0.7342f **FLOATING
C688 VDD.t77 GND 0.66626f **FLOATING
C689 VDD.t76 GND 0.82625f **FLOATING
C690 VDD.t322 GND 0.8657f **FLOATING
C691 VDD.n268 GND 1.18814f **FLOATING
C692 VDD.n277 GND 0.62723f **FLOATING
C693 VDD.n282 GND 0.66083f **FLOATING
C694 VDD.n288 GND 0.62723f **FLOATING
C695 VDD.n290 GND 0.54039f **FLOATING
C696 VDD.n291 GND 0.55997f **FLOATING
C697 VDD.n292 GND 0.72215f **FLOATING
C698 VDD.n293 GND 0.53954f **FLOATING
C699 VDD.n316 GND 1.57052f **FLOATING
C700 VDD.t279 GND 1.843f **FLOATING
C701 VDD.t150 GND 2.30123f **FLOATING
C702 VDD.t154 GND 2.30123f **FLOATING
C703 VDD.t152 GND 2.30123f **FLOATING
C704 VDD.t148 GND 1.74127f **FLOATING
C705 VDD.n317 GND 0.72215f **FLOATING
C706 VDD.n318 GND 0.55997f **FLOATING
C707 VDD.t276 GND 1.29417f **FLOATING
C708 VDD.t285 GND 1.35663f **FLOATING
C709 VDD.t47 GND 0.82406f **FLOATING
C710 VDD.t46 GND 0.66626f **FLOATING
C711 VDD.t44 GND 0.74735f **FLOATING
C712 VDD.t43 GND 0.7342f **FLOATING
C713 VDD.t41 GND 0.66626f **FLOATING
C714 VDD.t40 GND 0.82625f **FLOATING
C715 VDD.t282 GND 0.8657f **FLOATING
C716 VDD.n319 GND 1.18814f **FLOATING
C717 VDD.n321 GND 0.97469f **FLOATING
C718 VDD.n322 GND 0.85942f **FLOATING
C719 VDD.n323 GND 0.69128f **FLOATING
C720 VDD.n324 GND 1.18814f **FLOATING
C721 VDD.t202 GND 0.8657f **FLOATING
C722 VDD.t56 GND 0.82625f **FLOATING
C723 VDD.t57 GND 0.66626f **FLOATING
C724 VDD.t59 GND 0.7342f **FLOATING
C725 VDD.t60 GND 0.74735f **FLOATING
C726 VDD.t62 GND 0.66626f **FLOATING
C727 VDD.t63 GND 0.82406f **FLOATING
C728 VDD.t205 GND 1.35663f **FLOATING
C729 VDD.t196 GND 1.29417f **FLOATING
C730 VDD.n325 GND 0.55997f **FLOATING
C731 VDD.n326 GND 0.72215f **FLOATING
C732 VDD.t16 GND 1.74127f **FLOATING
C733 VDD.t20 GND 2.30123f **FLOATING
C734 VDD.t22 GND 2.30123f **FLOATING
C735 VDD.t18 GND 2.30123f **FLOATING
C736 VDD.t199 GND 1.843f **FLOATING
C737 VDD.n327 GND 1.57052f **FLOATING
C738 VDD.n330 GND 1.18814f **FLOATING
C739 VDD.t222 GND 0.8657f **FLOATING
C740 VDD.t28 GND 0.82625f **FLOATING
C741 VDD.t29 GND 0.66626f **FLOATING
C742 VDD.t31 GND 0.7342f **FLOATING
C743 VDD.t24 GND 0.74735f **FLOATING
C744 VDD.t26 GND 0.66626f **FLOATING
C745 VDD.t27 GND 0.82406f **FLOATING
C746 VDD.t225 GND 1.35663f **FLOATING
C747 VDD.t216 GND 1.29417f **FLOATING
C748 VDD.n331 GND 0.55997f **FLOATING
C749 VDD.n332 GND 0.72215f **FLOATING
C750 VDD.t124 GND 1.74127f **FLOATING
C751 VDD.t126 GND 2.30123f **FLOATING
C752 VDD.t122 GND 2.30123f **FLOATING
C753 VDD.t128 GND 2.30123f **FLOATING
C754 VDD.t219 GND 1.843f **FLOATING
C755 VDD.n333 GND 1.57052f **FLOATING
C756 VDD.n336 GND 1.18814f **FLOATING
C757 VDD.t242 GND 0.8657f **FLOATING
C758 VDD.t32 GND 0.82625f **FLOATING
C759 VDD.t33 GND 0.66626f **FLOATING
C760 VDD.t35 GND 0.7342f **FLOATING
C761 VDD.t36 GND 0.74735f **FLOATING
C762 VDD.t38 GND 0.66626f **FLOATING
C763 VDD.t39 GND 0.82406f **FLOATING
C764 VDD.t245 GND 1.35663f **FLOATING
C765 VDD.t236 GND 1.29417f **FLOATING
C766 VDD.n337 GND 0.55997f **FLOATING
C767 VDD.n338 GND 0.72215f **FLOATING
C768 VDD.t130 GND 1.74127f **FLOATING
C769 VDD.t131 GND 2.30123f **FLOATING
C770 VDD.t132 GND 2.30123f **FLOATING
C771 VDD.t133 GND 2.30123f **FLOATING
C772 VDD.t239 GND 1.843f **FLOATING
C773 VDD.n339 GND 1.57052f **FLOATING
C774 VDD.n342 GND 1.18814f **FLOATING
C775 VDD.t262 GND 0.8657f **FLOATING
C776 VDD.t4 GND 0.82625f **FLOATING
C777 VDD.t5 GND 0.66626f **FLOATING
C778 VDD.t7 GND 0.7342f **FLOATING
C779 VDD.t0 GND 0.74735f **FLOATING
C780 VDD.t2 GND 0.66626f **FLOATING
C781 VDD.t3 GND 0.82406f **FLOATING
C782 VDD.t265 GND 1.35663f **FLOATING
C783 VDD.t256 GND 1.29417f **FLOATING
C784 VDD.n343 GND 0.55997f **FLOATING
C785 VDD.n344 GND 0.72215f **FLOATING
C786 VDD.t48 GND 1.74127f **FLOATING
C787 VDD.t52 GND 2.30123f **FLOATING
C788 VDD.t54 GND 2.30123f **FLOATING
C789 VDD.t50 GND 2.30123f **FLOATING
C790 VDD.t259 GND 1.843f **FLOATING
C791 VDD.n345 GND 1.57052f **FLOATING
C792 VDD.n346 GND 2.94185f **FLOATING
C793 VDD.n347 GND 2.30652f **FLOATING
C794 VDD.n352 GND 0.62723f **FLOATING
C795 VDD.n354 GND 0.54039f **FLOATING
C796 VDD.n355 GND 0.53954f **FLOATING
C797 VDD.n360 GND 0.66083f **FLOATING
C798 VDD.n361 GND 0.55333f **FLOATING
C799 VDD.n374 GND 1.57052f **FLOATING
C800 VDD.t359 GND 1.843f **FLOATING
C801 VDD.t189 GND 2.30123f **FLOATING
C802 VDD.t188 GND 2.30123f **FLOATING
C803 VDD.t187 GND 2.30123f **FLOATING
C804 VDD.t186 GND 1.74127f **FLOATING
C805 VDD.n375 GND 0.72215f **FLOATING
C806 VDD.n376 GND 0.55997f **FLOATING
C807 VDD.t356 GND 1.29417f **FLOATING
C808 VDD.t365 GND 1.35663f **FLOATING
C809 VDD.t117 GND 0.82406f **FLOATING
C810 VDD.t116 GND 0.66626f **FLOATING
C811 VDD.t114 GND 0.74735f **FLOATING
C812 VDD.t121 GND 0.7342f **FLOATING
C813 VDD.t119 GND 0.66626f **FLOATING
C814 VDD.t118 GND 0.82625f **FLOATING
C815 VDD.t362 GND 0.8657f **FLOATING
C816 VDD.n377 GND 1.18814f **FLOATING
C817 VDD.n380 GND 2.1138f **FLOATING
C818 Vout.t8 GND 9.89108f **FLOATING
C819 Vout.n2 GND 0.87322f **FLOATING
C820 Vout.n8 GND 0.71869f **FLOATING
C821 Cap0.t2 GND 0.80305f **FLOATING
C822 Cap0.n0 GND 4.20576f **FLOATING
C823 Cap0.t3 GND 0.80305f **FLOATING
C824 Cap0.n1 GND 3.30291f **FLOATING
C825 Cap1.t2 GND 1.00469f **FLOATING
C826 Cap1.n0 GND 5.07237f **FLOATING
C827 Cap1.t3 GND 1.00469f **FLOATING
C828 Cap1.n1 GND 3.98558f **FLOATING
C829 Cap2.t2 GND 0.88121f **FLOATING
C830 Cap2.n0 GND 4.34983f **FLOATING
C831 Cap2.t3 GND 0.88121f **FLOATING
C832 Cap2.n1 GND 3.35083f **FLOATING
C833 Vin.n0 GND 0.6893f **FLOATING
C834 Vin.n3 GND 0.87747f **FLOATING
C835 VDD05.t19 GND 3.4414f **FLOATING
C836 VDD05.t15 GND 1.92482f **FLOATING
C837 VDD05.n50 GND 2.35562f **FLOATING
C838 VDD05.t3 GND 3.4414f **FLOATING
C839 VDD05.t7 GND 1.92482f **FLOATING
C840 VDD05.n51 GND 2.35562f **FLOATING
C841 VDD05.t18 GND 3.4414f **FLOATING
C842 VDD05.t14 GND 1.92482f **FLOATING
C843 VDD05.n52 GND 2.35562f **FLOATING
C844 VDD05.t2 GND 3.4414f **FLOATING
C845 VDD05.t6 GND 1.92482f **FLOATING
C846 VDD05.n53 GND 2.35562f **FLOATING
C847 VDD05.t17 GND 3.4414f **FLOATING
C848 VDD05.t13 GND 1.92482f **FLOATING
C849 VDD05.n54 GND 2.35562f **FLOATING
C850 VDD05.t1 GND 3.4414f **FLOATING
C851 VDD05.t5 GND 1.92482f **FLOATING
C852 VDD05.n55 GND 2.35562f **FLOATING
C853 VDD05.t16 GND 3.4414f **FLOATING
C854 VDD05.t12 GND 1.92482f **FLOATING
C855 VDD05.n56 GND 2.45431f **FLOATING
C856 VDD05.t8 GND 1.92482f **FLOATING
C857 VDD05.n57 GND 1.11351f **FLOATING
C858 VDD05.t0 GND 3.4414f **FLOATING
C859 VDD05.t4 GND 1.92482f **FLOATING
C860 VDD05.n58 GND 2.42043f **FLOATING
C861 VDD05.n59 GND 1.07425f **FLOATING
C862 VDD05.t9 GND 1.92482f **FLOATING
C863 VDD05.n60 GND 1.04999f **FLOATING
C864 VDD05.n61 GND 1.18142f **FLOATING
C865 VDD05.t10 GND 1.92482f **FLOATING
C866 VDD05.n62 GND 1.0986f **FLOATING
C867 VDD05.n63 GND 1.18837f **FLOATING
C868 VDD05.t11 GND 1.92482f **FLOATING
C869 VDD05.n64 GND 1.1109f **FLOATING
C870 VDD05.n65 GND 3.87867f **FLOATING
C871 VDD05.n66 GND 0.94631f **FLOATING
C872 VDD05.n67 GND 1.26586f **FLOATING
C873 VDD05.n76 GND 0.60266f **FLOATING
C874 VDD05.n77 GND 0.6448f **FLOATING
C875 VDD05.n78 GND 0.77955f **FLOATING
C876 VbiasP.t0 GND 4.15298f **FLOATING
C877 VbiasP.t4 GND 0.55714f **FLOATING
C878 VbiasP.n0 GND 2.9469f **FLOATING
C879 VbiasP.t3 GND 0.55714f **FLOATING
C880 VbiasP.n1 GND 4.82513f **FLOATING
C881 VbiasP.t2 GND 0.68167f **FLOATING
C882 VbiasP.n2 GND 3.85544f **FLOATING
C883 VbiasP.t1 GND 0.68167f **FLOATING
C884 VbiasP.n3 GND 3.66967f **FLOATING
C885 VbiasN.t0 GND 3.12524f **FLOATING
C886 VbiasN.n0 GND 0.65887f **FLOATING
C887 VbiasN.n1 GND 1.33364f **FLOATING
C888 VbiasN.n2 GND 1.35778f **FLOATING
C889 VbiasN.n3 GND 1.25589f **FLOATING
