* NGSPICE file created from B04_BMR.ext - technology: gf180mcuD

.subckt nfet_03v3_6AMVAX a_n626_n296# a_n488_n110# a_400_n110# a_n400_n202#
X0 a_400_n110# a_n400_n202# a_n488_n110# a_n626_n296# nfet_03v3 ad=0.484p pd=3.08u as=0.484p ps=3.08u w=1.1u l=4u
C0 a_400_n110# a_n400_n202# 0.03828f
C1 a_400_n110# a_n488_n110# 0.01101f
C2 a_n400_n202# a_n488_n110# 0.03828f
C3 a_400_n110# a_n626_n296# 0.15486f
C4 a_n488_n110# a_n626_n296# 0.15486f
C5 a_n400_n202# a_n626_n296# 2.73981f
.ends

.subckt nfet_03v3_TTHT8G a_400_n220# a_n400_n312# a_n626_n406# a_n488_n220#
X0 a_400_n220# a_n400_n312# a_n488_n220# a_n626_n406# nfet_03v3 ad=0.968p pd=5.28u as=0.968p ps=5.28u w=2.2u l=4u
C0 a_400_n220# a_n400_n312# 0.07728f
C1 a_400_n220# a_n488_n220# 0.02223f
C2 a_n400_n312# a_n488_n220# 0.07728f
C3 a_400_n220# a_n626_n406# 0.2737f
C4 a_n488_n220# a_n626_n406# 0.2737f
C5 a_n400_n312# a_n626_n406# 2.73997f
.ends

.subckt pfet_03v3_SAK7G2 a_n400_n1392# w_n650_n1510# a_400_n1300# a_n488_n1300# VSUBS
X0 a_400_n1300# a_n400_n1392# a_n488_n1300# w_n650_n1510# pfet_03v3 ad=5.72p pd=26.88u as=5.72p ps=26.88u w=13u l=4u
C0 a_n488_n1300# w_n650_n1510# 1.82723f
C1 a_n488_n1300# a_n400_n1392# 0.46012f
C2 a_400_n1300# w_n650_n1510# 1.82723f
C3 a_400_n1300# a_n400_n1392# 0.46012f
C4 w_n650_n1510# a_n400_n1392# 2.83014f
C5 a_n488_n1300# a_400_n1300# 0.13235f
C6 a_n400_n1392# VSUBS 0.23142f
C7 w_n650_n1510# VSUBS 13.1556f
.ends

.subckt B04_diff_amp V+ V- Vbias m1_n850_170# m1_n960_1530# VDD VSS Vo
XXM1 VSS m1_n960_1530# m1_n850_170# V+ nfet_03v3_6AMVAX
XXM2 VSS Vbias VSS m1_n850_170# nfet_03v3_TTHT8G
XXM3 VSS Vo m1_n850_170# V- nfet_03v3_6AMVAX
XXM4 m1_n960_1530# VDD Vo VDD VSS pfet_03v3_SAK7G2
XXM5 m1_n960_1530# VDD m1_n960_1530# VDD VSS pfet_03v3_SAK7G2
C0 Vo m1_n850_170# -0.01058f
C1 V- V+ 0.02023f
C2 m1_n850_170# Vbias 0.19121f
C3 V+ m1_n850_170# 0.09281f
C4 V- m1_n960_1530# 0.00608f
C5 m1_n960_1530# m1_n850_170# -0.00786f
C6 Vo m1_n960_1530# 1.43492f
C7 V+ Vbias 0.0249f
C8 V- VDD 0.0058f
C9 V+ m1_n960_1530# 0.10815f
C10 VDD m1_n850_170# 0.00674f
C11 VDD Vo -0.18006f
C12 VDD V+ 0.01622f
C13 V- m1_n850_170# 0.09281f
C14 V- Vo 0.14912f
C15 VDD m1_n960_1530# 1.17744f
C16 VDD VSS -0.04366f
C17 Vo VSS 0.87336f
C18 m1_n850_170# VSS 1.40547f
C19 V- VSS 0.34225f
C20 Vbias VSS 0.79992f
C21 m1_n960_1530# VSS 0.86796f
C22 V+ VSS 0.3437f
.ends

.subckt ppolyf_u_1k_2Q22HA a_n4972_n4434# a_1000_4100# a_2920_n4222# a_n3800_n4222#
+ a_2440_n4222# a_n3320_n4222# a_n920_4100# a_3880_4100# a_1960_4100# a_2920_4100#
+ a_n1880_4100# a_n4760_4100# a_n2840_4100# a_n3800_4100# a_3400_n4222# a_520_4100#
+ a_n1400_n4222# a_3880_n4222# a_40_n4222# a_n440_4100# a_n4280_n4222# a_n4760_n4222#
+ a_4360_4100# a_2440_4100# a_1480_4100# a_3400_4100# a_1000_n4222# a_n1880_n4222#
+ a_n2360_4100# a_n4280_4100# a_n440_n4222# a_n920_n4222# a_n1400_4100# a_n3320_4100#
+ a_40_4100# a_4360_n4222# a_520_n4222# a_1960_n4222# a_n2840_n4222# a_1480_n4222#
+ a_n2360_n4222#
X0 a_n3320_4100# a_n3320_n4222# a_n4972_n4434# ppolyf_u_1k r_width=2u r_length=41u
X1 a_n2360_4100# a_n2360_n4222# a_n4972_n4434# ppolyf_u_1k r_width=2u r_length=41u
X2 a_n2840_4100# a_n2840_n4222# a_n4972_n4434# ppolyf_u_1k r_width=2u r_length=41u
X3 a_n1400_4100# a_n1400_n4222# a_n4972_n4434# ppolyf_u_1k r_width=2u r_length=41u
X4 a_1000_4100# a_1000_n4222# a_n4972_n4434# ppolyf_u_1k r_width=2u r_length=41u
X5 a_n1880_4100# a_n1880_n4222# a_n4972_n4434# ppolyf_u_1k r_width=2u r_length=41u
X6 a_520_4100# a_520_n4222# a_n4972_n4434# ppolyf_u_1k r_width=2u r_length=41u
X7 a_4360_4100# a_4360_n4222# a_n4972_n4434# ppolyf_u_1k r_width=2u r_length=41u
X8 a_3880_4100# a_3880_n4222# a_n4972_n4434# ppolyf_u_1k r_width=2u r_length=41u
X9 a_n440_4100# a_n440_n4222# a_n4972_n4434# ppolyf_u_1k r_width=2u r_length=41u
X10 a_n920_4100# a_n920_n4222# a_n4972_n4434# ppolyf_u_1k r_width=2u r_length=41u
X11 a_n4280_4100# a_n4280_n4222# a_n4972_n4434# ppolyf_u_1k r_width=2u r_length=41u
X12 a_40_4100# a_40_n4222# a_n4972_n4434# ppolyf_u_1k r_width=2u r_length=41u
X13 a_n4760_4100# a_n4760_n4222# a_n4972_n4434# ppolyf_u_1k r_width=2u r_length=41u
X14 a_n3800_4100# a_n3800_n4222# a_n4972_n4434# ppolyf_u_1k r_width=2u r_length=41u
X15 a_3400_4100# a_3400_n4222# a_n4972_n4434# ppolyf_u_1k r_width=2u r_length=41u
X16 a_2440_4100# a_2440_n4222# a_n4972_n4434# ppolyf_u_1k r_width=2u r_length=41u
X17 a_2920_4100# a_2920_n4222# a_n4972_n4434# ppolyf_u_1k r_width=2u r_length=41u
X18 a_1480_4100# a_1480_n4222# a_n4972_n4434# ppolyf_u_1k r_width=2u r_length=41u
X19 a_1960_4100# a_1960_n4222# a_n4972_n4434# ppolyf_u_1k r_width=2u r_length=41u
C0 a_520_4100# a_40_4100# 0.04464f
C1 a_2440_n4222# a_1960_n4222# 0.04464f
C2 a_n3320_n4222# a_n3800_n4222# 0.04464f
C3 a_n2840_n4222# a_n2360_n4222# 0.04464f
C4 a_n1880_n4222# a_n1400_n4222# 0.04464f
C5 a_n3320_4100# a_n2840_4100# 0.04464f
C6 a_4360_n4222# a_3880_n4222# 0.04464f
C7 a_n1880_n4222# a_n2360_n4222# 0.04464f
C8 a_1960_4100# a_1480_4100# 0.04464f
C9 a_n4280_4100# a_n4760_4100# 0.04464f
C10 a_n4280_n4222# a_n3800_n4222# 0.04464f
C11 a_n440_n4222# a_n920_n4222# 0.04464f
C12 a_1000_n4222# a_520_n4222# 0.04464f
C13 a_n440_n4222# a_40_n4222# 0.04464f
C14 a_4360_4100# a_3880_4100# 0.04464f
C15 a_3400_4100# a_3880_4100# 0.04464f
C16 a_n4760_n4222# a_n4280_n4222# 0.04464f
C17 a_n1400_4100# a_n920_4100# 0.04464f
C18 a_1000_4100# a_520_4100# 0.04464f
C19 a_1480_n4222# a_1960_n4222# 0.04464f
C20 a_n440_4100# a_40_4100# 0.04464f
C21 a_2920_4100# a_3400_4100# 0.04464f
C22 a_n3320_4100# a_n3800_4100# 0.04464f
C23 a_n1400_n4222# a_n920_n4222# 0.04464f
C24 a_3880_n4222# a_3400_n4222# 0.04464f
C25 a_3400_n4222# a_2920_n4222# 0.04464f
C26 a_2440_n4222# a_2920_n4222# 0.04464f
C27 a_n2360_4100# a_n2840_4100# 0.04464f
C28 a_2920_4100# a_2440_4100# 0.04464f
C29 a_1960_4100# a_2440_4100# 0.04464f
C30 a_n4280_4100# a_n3800_4100# 0.04464f
C31 a_n440_4100# a_n920_4100# 0.04464f
C32 a_40_n4222# a_520_n4222# 0.04464f
C33 a_n1880_4100# a_n2360_4100# 0.04464f
C34 a_n1880_4100# a_n1400_4100# 0.04464f
C35 a_n2840_n4222# a_n3320_n4222# 0.04464f
C36 a_1000_n4222# a_1480_n4222# 0.04464f
C37 a_1480_4100# a_1000_4100# 0.04464f
C38 a_4360_n4222# a_n4972_n4434# 0.50375f
C39 a_4360_4100# a_n4972_n4434# 0.50375f
C40 a_3880_n4222# a_n4972_n4434# 0.46703f
C41 a_3880_4100# a_n4972_n4434# 0.46703f
C42 a_3400_n4222# a_n4972_n4434# 0.46628f
C43 a_3400_4100# a_n4972_n4434# 0.46628f
C44 a_2920_n4222# a_n4972_n4434# 0.46577f
C45 a_2920_4100# a_n4972_n4434# 0.46577f
C46 a_2440_n4222# a_n4972_n4434# 0.46576f
C47 a_2440_4100# a_n4972_n4434# 0.46576f
C48 a_1960_n4222# a_n4972_n4434# 0.46576f
C49 a_1960_4100# a_n4972_n4434# 0.46576f
C50 a_1480_n4222# a_n4972_n4434# 0.46576f
C51 a_1480_4100# a_n4972_n4434# 0.46576f
C52 a_1000_n4222# a_n4972_n4434# 0.46576f
C53 a_1000_4100# a_n4972_n4434# 0.46576f
C54 a_520_n4222# a_n4972_n4434# 0.46576f
C55 a_520_4100# a_n4972_n4434# 0.46576f
C56 a_40_n4222# a_n4972_n4434# 0.46576f
C57 a_40_4100# a_n4972_n4434# 0.46576f
C58 a_n440_n4222# a_n4972_n4434# 0.46576f
C59 a_n440_4100# a_n4972_n4434# 0.46576f
C60 a_n920_n4222# a_n4972_n4434# 0.46576f
C61 a_n920_4100# a_n4972_n4434# 0.46576f
C62 a_n1400_n4222# a_n4972_n4434# 0.46576f
C63 a_n1400_4100# a_n4972_n4434# 0.46576f
C64 a_n1880_n4222# a_n4972_n4434# 0.46576f
C65 a_n1880_4100# a_n4972_n4434# 0.46576f
C66 a_n2360_n4222# a_n4972_n4434# 0.46576f
C67 a_n2360_4100# a_n4972_n4434# 0.46576f
C68 a_n2840_n4222# a_n4972_n4434# 0.46576f
C69 a_n2840_4100# a_n4972_n4434# 0.46576f
C70 a_n3320_n4222# a_n4972_n4434# 0.46577f
C71 a_n3320_4100# a_n4972_n4434# 0.46577f
C72 a_n3800_n4222# a_n4972_n4434# 0.46628f
C73 a_n3800_4100# a_n4972_n4434# 0.46628f
C74 a_n4280_n4222# a_n4972_n4434# 0.46703f
C75 a_n4280_4100# a_n4972_n4434# 0.46703f
C76 a_n4760_n4222# a_n4972_n4434# 0.50375f
C77 a_n4760_4100# a_n4972_n4434# 0.50375f
.ends

.subckt pfet_03v3_6SMZHP a_4000_n50# w_n4250_n260# a_n4000_n142# a_n4088_n50# VSUBS
X0 a_4000_n50# a_n4000_n142# a_n4088_n50# w_n4250_n260# pfet_03v3 ad=0.22p pd=1.88u as=0.22p ps=1.88u w=0.5u l=40u
C0 a_n4000_n142# a_4000_n50# 0.01858f
C1 a_n4000_n142# a_n4088_n50# 0.01858f
C2 a_4000_n50# w_n4250_n260# 0.10243f
C3 a_n4088_n50# w_n4250_n260# 0.10243f
C4 a_n4000_n142# w_n4250_n260# 25.2687f
C5 a_4000_n50# VSUBS 0.00253f
C6 a_n4088_n50# VSUBS 0.00253f
C7 a_n4000_n142# VSUBS 1.70879f
C8 w_n4250_n260# VSUBS 16.2401f
.ends

.subckt pfet_03v3_M5A2ND a_400_n200# w_n650_n410# a_n488_n200# a_n400_n292# VSUBS
X0 a_400_n200# a_n400_n292# a_n488_n200# w_n650_n410# pfet_03v3 ad=0.88p pd=4.88u as=0.88p ps=4.88u w=2u l=4u
C0 a_n400_n292# a_400_n200# 0.07019f
C1 a_n400_n292# a_n488_n200# 0.07019f
C2 a_400_n200# w_n650_n410# 0.31173f
C3 a_n488_n200# w_n650_n410# 0.31173f
C4 a_n488_n200# a_400_n200# 0.02019f
C5 a_n400_n292# w_n650_n410# 2.74794f
C6 a_n400_n292# VSUBS 0.18943f
C7 w_n650_n410# VSUBS 3.82593f
.ends

.subckt nfet_03v3_LH5LWX a_n188_n100# a_n100_n192# a_100_n100# a_n326_n286#
X0 a_100_n100# a_n100_n192# a_n188_n100# a_n326_n286# nfet_03v3 ad=0.44p pd=2.88u as=0.44p ps=2.88u w=1u l=1u
C0 a_n188_n100# a_100_n100# 0.03511f
C1 a_100_n100# a_n100_n192# 0.02094f
C2 a_n188_n100# a_n100_n192# 0.02094f
C3 a_100_n100# a_n326_n286# 0.144f
C4 a_n188_n100# a_n326_n286# 0.144f
C5 a_n100_n192# a_n326_n286# 0.80032f
.ends

.subckt nfet_03v3_DUBMLQ a_n1226_n286# a_n1088_n100# a_n1000_n192# a_1000_n100#
X0 a_1000_n100# a_n1000_n192# a_n1088_n100# a_n1226_n286# nfet_03v3 ad=0.44p pd=2.88u as=0.44p ps=2.88u w=1u l=10u
C0 a_1000_n100# a_n1000_n192# 0.03793f
C1 a_n1088_n100# a_n1000_n192# 0.03793f
C2 a_1000_n100# a_n1226_n286# 0.14911f
C3 a_n1088_n100# a_n1226_n286# 0.14911f
C4 a_n1000_n192# a_n1226_n286# 6.60446f
.ends

.subckt nfet_03v3_GPTQ69 a_n400_n1092# a_n626_n1186# a_400_n1000# a_n488_n1000#
X0 a_400_n1000# a_n400_n1092# a_n488_n1000# a_n626_n1186# nfet_03v3 ad=4.4p pd=20.88u as=4.4p ps=20.88u w=10u l=4u
C0 a_n488_n1000# a_400_n1000# 0.10176f
C1 a_400_n1000# a_n400_n1092# 0.35377f
C2 a_n488_n1000# a_n400_n1092# 0.35377f
C3 a_400_n1000# a_n626_n1186# 1.10097f
C4 a_n488_n1000# a_n626_n1186# 1.10097f
C5 a_n400_n1092# a_n626_n1186# 2.78216f
.ends

.subckt nfet_03v3_CKM2XL a_400_n4348# a_n400_n4440# a_n400_n2208# a_n488_n4348# a_400_116#
+ a_n488_2348# a_n400_2256# a_n626_n4534# a_400_n2116# a_n400_24# a_n488_n2116# a_400_2348#
+ a_n488_116#
X0 a_400_2348# a_n400_2256# a_n488_2348# a_n626_n4534# nfet_03v3 ad=4.4p pd=20.88u as=4.4p ps=20.88u w=10u l=4u
X1 a_400_n2116# a_n400_n2208# a_n488_n2116# a_n626_n4534# nfet_03v3 ad=4.4p pd=20.88u as=4.4p ps=20.88u w=10u l=4u
X2 a_400_n4348# a_n400_n4440# a_n488_n4348# a_n626_n4534# nfet_03v3 ad=4.4p pd=20.88u as=4.4p ps=20.88u w=10u l=4u
X3 a_400_116# a_n400_24# a_n488_116# a_n626_n4534# nfet_03v3 ad=4.4p pd=20.88u as=4.4p ps=20.88u w=10u l=4u
C0 a_n488_2348# a_n488_116# 0.0083f
C1 a_400_116# a_400_2348# 0.0083f
C2 a_400_n2116# a_400_n4348# 0.0083f
C3 a_n488_2348# a_400_2348# 0.10176f
C4 a_n400_24# a_n400_2256# 0.75163f
C5 a_400_n2116# a_n488_n2116# 0.10176f
C6 a_n488_116# a_n488_n2116# 0.0083f
C7 a_n400_n4440# a_n400_n2208# 0.75163f
C8 a_n400_n2208# a_n488_n2116# 0.35377f
C9 a_n488_n4348# a_400_n4348# 0.10176f
C10 a_400_2348# a_n400_2256# 0.35377f
C11 a_n488_116# a_n400_24# 0.35377f
C12 a_n400_n2208# a_n400_24# 0.75163f
C13 a_400_n2116# a_n400_n2208# 0.35377f
C14 a_n400_n4440# a_n488_n4348# 0.35377f
C15 a_n488_n4348# a_n488_n2116# 0.0083f
C16 a_n488_2348# a_n400_2256# 0.35377f
C17 a_n400_n4440# a_400_n4348# 0.35377f
C18 a_400_116# a_n400_24# 0.35377f
C19 a_400_116# a_n488_116# 0.10176f
C20 a_400_n2116# a_400_116# 0.0083f
C21 a_400_n4348# a_n626_n4534# 1.08084f
C22 a_n488_n4348# a_n626_n4534# 1.08084f
C23 a_n400_n4440# a_n626_n4534# 1.77884f
C24 a_400_n2116# a_n626_n4534# 1.06071f
C25 a_n488_n2116# a_n626_n4534# 1.06071f
C26 a_n400_n2208# a_n626_n4534# 0.77552f
C27 a_400_116# a_n626_n4534# 1.06071f
C28 a_n488_116# a_n626_n4534# 1.06071f
C29 a_n400_24# a_n626_n4534# 0.77552f
C30 a_400_2348# a_n626_n4534# 1.08084f
C31 a_n488_2348# a_n626_n4534# 1.08084f
C32 a_n400_2256# a_n626_n4534# 1.77884f
.ends

.subckt B04_BMR VbiasN VbiasP VDD GND
XB04_diff_amp_0 B04_diff_amp_0/V+ VbiasN VbiasN B04_diff_amp_0/m1_n850_170# B04_diff_amp_0/m1_n960_1530#
+ VDD GND VbiasP B04_diff_amp
XXR2 GND m1_12350_5340# m1_13790_n3050# m1_7070_n3050# m1_13790_n3050# m1_8030_n3050#
+ m1_10430_5340# m1_15230_5340# m1_13310_5340# m1_14270_5340# m1_9470_5340# m1_6590_5340#
+ m1_8510_5340# m1_7550_5340# m1_14750_n3050# m1_11390_5340# m1_9950_n3050# m1_14750_n3050#
+ m1_10910_n3050# m1_10430_5340# m1_7070_n3050# m1_n2800_n2360# m1_15230_5340# m1_13310_5340#
+ m1_12350_5340# m1_14270_5340# m1_11870_n3050# m1_8990_n3050# m1_8510_5340# m1_6590_5340#
+ m1_10910_n3050# m1_9950_n3050# m1_9470_5340# m1_7550_5340# m1_11390_5340# GND m1_11870_n3050#
+ m1_12830_n3050# m1_8030_n3050# m1_12830_n3050# m1_8990_n3050# ppolyf_u_1k_2Q22HA
XXM1 m1_n3230_200# VDD m1_n3230_200# VDD GND pfet_03v3_6SMZHP
XXM2 VbiasN VDD VDD VbiasP GND pfet_03v3_M5A2ND
XXM3 B04_diff_amp_0/V+ VDD VDD VbiasP GND pfet_03v3_M5A2ND
XXM4 VbiasP m1_n1350_150# VbiasN GND nfet_03v3_LH5LWX
XXM5 GND GND VbiasN m1_n1350_150# nfet_03v3_DUBMLQ
XXM6 VbiasN GND GND VbiasN nfet_03v3_GPTQ69
XXM7 m1_n2800_n2360# VbiasN VbiasN B04_diff_amp_0/V+ m1_n2800_n2360# B04_diff_amp_0/V+
+ VbiasN GND m1_n2800_n2360# VbiasN B04_diff_amp_0/V+ m1_n2800_n2360# B04_diff_amp_0/V+
+ nfet_03v3_CKM2XL
XXM8 m1_n3230_200# VDD m1_n2310_530# m1_n2310_530# GND pfet_03v3_6SMZHP
XXM9 m1_n1350_150# VDD m1_n2310_530# m1_n2310_530# GND pfet_03v3_6SMZHP
C0 m1_12830_n3050# m1_11870_n3050# 0.04518f
C1 VbiasN m1_n2310_530# 0.05275f
C2 VbiasN m1_n1350_150# 0.78401f
C3 m1_n2310_530# VDD 0.72544f
C4 VDD m1_n1350_150# 0.36709f
C5 m1_6590_5340# VbiasP 0
C6 VbiasP B04_diff_amp_0/V+ 0.93918f
C7 m1_12350_5340# m1_11390_5340# 0.0452f
C8 m1_n3230_200# m1_n2310_530# 0.186f
C9 m1_n3230_200# m1_n1350_150# 0.0044f
C10 m1_6590_5340# B04_diff_amp_0/V+ 0
C11 m1_12350_5340# m1_13310_5340# 0.0452f
C12 m1_n2310_530# VbiasP 0.18082f
C13 VbiasP m1_n1350_150# 0.40565f
C14 VbiasN B04_diff_amp_0/m1_n960_1530# 0.00226f
C15 B04_diff_amp_0/m1_n960_1530# VDD 0.00274f
C16 B04_diff_amp_0/V+ m1_n1350_150# -0
C17 m1_15230_5340# m1_14270_5340# 0.0452f
C18 m1_10910_n3050# m1_11870_n3050# 0.04518f
C19 m1_9950_n3050# m1_8990_n3050# 0.04518f
C20 m1_9470_5340# m1_10430_5340# 0.0452f
C21 m1_8990_n3050# m1_8030_n3050# 0.04518f
C22 m1_14270_5340# m1_13310_5340# 0.0452f
C23 VbiasN B04_diff_amp_0/m1_n850_170# 0.09098f
C24 m1_7070_n3050# m1_n2800_n2360# 0.04267f
C25 m1_n2310_530# m1_n1350_150# 0.2019f
C26 m1_8510_5340# m1_9470_5340# 0.0452f
C27 m1_6590_5340# m1_7550_5340# 0.0452f
C28 VbiasN m1_n2800_n2360# 2.67557f
C29 B04_diff_amp_0/m1_n960_1530# VbiasP 0.36608f
C30 m1_11390_5340# m1_10430_5340# 0.0452f
C31 m1_8510_5340# m1_7550_5340# 0.0452f
C32 VbiasN VDD 0.89279f
C33 m1_13790_n3050# m1_14750_n3050# 0.04518f
C34 VbiasN m1_n3230_200# 0.05815f
C35 m1_n3230_200# VDD 0.41401f
C36 VbiasN VbiasP 2.4194f
C37 B04_diff_amp_0/m1_n960_1530# m1_n2310_530# 0.0265f
C38 B04_diff_amp_0/m1_n960_1530# m1_n1350_150# 0
C39 VDD VbiasP 2.39525f
C40 B04_diff_amp_0/V+ B04_diff_amp_0/m1_n850_170# 0.02262f
C41 B04_diff_amp_0/V+ m1_n2800_n2360# -0.00493f
C42 m1_10910_n3050# m1_9950_n3050# 0.04518f
C43 m1_n2800_n2360# m1_8030_n3050# 0.00147f
C44 m1_7070_n3050# m1_8030_n3050# 0.04518f
C45 m1_13790_n3050# m1_12830_n3050# 0.04518f
C46 VbiasN m1_6590_5340# 0
C47 VbiasN B04_diff_amp_0/V+ 5.00216f
C48 VDD B04_diff_amp_0/V+ 0.11886f
C49 m1_n1350_150# GND 1.49384f
C50 m1_n2310_530# GND 0.372f
C51 m1_n3230_200# GND 0.11314f
C52 m1_n2800_n2360# GND 4.66841f
C53 B04_diff_amp_0/V+ GND 6.1525f
C54 VbiasN GND 9.26846f
C55 m1_15230_5340# GND 0.17473f
C56 m1_14750_n3050# GND 0.21733f
C57 m1_14270_5340# GND 0.155f
C58 m1_13790_n3050# GND 0.17304f
C59 m1_13310_5340# GND 0.1553f
C60 m1_12830_n3050# GND 0.17304f
C61 m1_12350_5340# GND 0.1553f
C62 m1_11870_n3050# GND 0.17304f
C63 m1_11390_5340# GND 0.1553f
C64 m1_10910_n3050# GND 0.17304f
C65 m1_10430_5340# GND 0.1553f
C66 m1_9950_n3050# GND 0.17304f
C67 m1_9470_5340# GND 0.1553f
C68 m1_8990_n3050# GND 0.17304f
C69 m1_8510_5340# GND 0.1553f
C70 m1_8030_n3050# GND 0.17304f
C71 m1_7550_5340# GND 0.155f
C72 m1_7070_n3050# GND 0.17829f
C73 m1_6590_5340# GND 0.17334f
C74 VDD GND -2.70301f
C75 VbiasP GND 0.93138f
C76 B04_diff_amp_0/m1_n850_170# GND -0.33976f
C77 B04_diff_amp_0/m1_n960_1530# GND -3.99891f
.ends
