* Extracted by KLayout with GF180MCU LVS runset on : 18/08/2026 17:52

.SUBCKT B04_VDD05 VbiasN VDD GND
X$1 \$17 VbiasN VDD \$16 \$31 \$15 \$14 GND B04_OTA_bias_ratio_5
X$3 \$31 \$15 \$41 VDD \$41 \$20 \$17 \$16 GND B04_OTA
R$1 GND GND GND 3750 ppolyf_u_1k L=30U W=8U
R$12 GND \$20 GND 300000 ppolyf_u_1k L=600U W=2U
R$43 VDD \$20 GND 300000 ppolyf_u_1k L=600U W=2U
.ENDS B04_VDD05

.SUBCKT B04_OTA Vbias1 Vbias2 Vout VDD Vin\x2d Vin+ Vbias3 Vbias0 GND
M$1 \$16 Vbias0 VDD VDD pfet_03v3 L=4U W=5U AS=1.75P AD=1.75P PS=8.9U PD=8.9U
M$3 Vout Vbias3 \$19 VDD pfet_03v3 L=4U W=5U AS=2.2P AD=2.2P PS=11.76U PD=11.76U
M$5 VDD \$11 \$19 VDD pfet_03v3 L=4U W=5U AS=2.2P AD=2.2P PS=11.76U PD=11.76U
M$6 VDD \$11 \$21 VDD pfet_03v3 L=4U W=5U AS=2.2P AD=2.2P PS=11.76U PD=11.76U
M$9 \$21 Vbias3 \$11 VDD pfet_03v3 L=4U W=5U AS=2.2P AD=2.2P PS=11.76U PD=11.76U
M$11 VDD VDD VDD VDD pfet_03v3 L=4U W=10U AS=4.4P AD=4.4P PS=23.52U PD=23.52U
M$15 \$5 Vin\x2d \$16 VDD pfet_03v3 L=1U W=2U AS=0.61P AD=0.61P PS=4.94U
+ PD=4.94U
M$19 \$9 Vin+ \$16 VDD pfet_03v3 L=1U W=2U AS=0.61P AD=0.61P PS=4.94U PD=4.94U
M$23 \$3 Vin+ \$16 VDD pfet_03v3 L=1U W=2U AS=0.61P AD=0.61P PS=4.94U PD=4.94U
M$27 \$4 Vin\x2d \$16 VDD pfet_03v3 L=1U W=2U AS=0.61P AD=0.61P PS=4.94U
+ PD=4.94U
M$31 VDD VDD VDD VDD pfet_03v3 L=1U W=2U AS=0.88P AD=0.88P PS=7.52U PD=7.52U
M$35 \$2 Vbias2 \$5 GND nfet_03v3 L=1U W=2U AS=0.88P AD=0.88P PS=5.76U PD=5.76U
M$36 \$9 Vbias2 \$7 GND nfet_03v3 L=1U W=2U AS=0.88P AD=0.88P PS=5.76U PD=5.76U
M$37 GND GND GND GND nfet_03v3 L=1U W=4U AS=1.76P AD=1.76P PS=11.52U PD=11.52U
M$43 GND \$5 \$2 GND nfet_03v3 L=4U W=1U AS=0.44P AD=0.44P PS=3.76U PD=3.76U
M$44 \$3 Vbias1 GND GND nfet_03v3 L=4U W=1U AS=0.44P AD=0.44P PS=3.76U PD=3.76U
M$45 \$3 \$5 GND GND nfet_03v3 L=4U W=1U AS=0.44P AD=0.44P PS=3.76U PD=3.76U
M$46 GND \$9 \$4 GND nfet_03v3 L=4U W=1U AS=0.44P AD=0.44P PS=3.76U PD=3.76U
M$47 GND Vbias1 \$4 GND nfet_03v3 L=4U W=1U AS=0.44P AD=0.44P PS=3.76U PD=3.76U
M$48 \$7 \$9 GND GND nfet_03v3 L=4U W=1U AS=0.44P AD=0.44P PS=3.76U PD=3.76U
M$49 GND GND GND GND nfet_03v3 L=4U W=3U AS=1.32P AD=1.32P PS=11.28U PD=11.28U
M$52 \$3 Vbias2 \$11 GND nfet_03v3 L=4U W=1U AS=0.44P AD=0.44P PS=3.76U PD=3.76U
M$58 \$4 Vbias2 Vout GND nfet_03v3 L=4U W=1U AS=0.44P AD=0.44P PS=3.76U PD=3.76U
.ENDS B04_OTA

.SUBCKT B04_OTA_bias_ratio_5 Vbias3 VbiasN VDD Vbias0 Vbias1 Vbias2 VbiasP GND
M$1 Vbias2 VbiasP VDD VDD pfet_03v3 L=4U W=25U AS=11P AD=11P PS=50.88U PD=50.88U
M$2 Vbias3 VbiasN GND GND nfet_03v3 L=4U W=50U AS=22P AD=22P PS=100.88U
+ PD=100.88U
M$3 \$10 Vbias1 GND GND nfet_03v3 L=4U W=1U AS=0.44P AD=0.44P PS=2.88U PD=2.88U
M$4 Vbias1 Vbias2 \$10 GND nfet_03v3 L=4U W=1U AS=0.44P AD=0.44P PS=2.88U
+ PD=2.88U
M$5 Vbias3 VDD Vbias0 GND nfet_03v3 L=4U W=10U AS=4.4P AD=4.4P PS=20.88U
+ PD=20.88U
M$6 Vbias0 Vbias3 \$15 VDD pfet_03v3 L=4U W=5U AS=2.2P AD=2.2P PS=10.88U
+ PD=10.88U
M$7 \$15 Vbias0 VDD VDD pfet_03v3 L=4U W=5U AS=2.2P AD=2.2P PS=10.88U PD=10.88U
M$8 Vbias1 GND Vbias2 VDD pfet_03v3 L=4U W=5U AS=2.2P AD=2.2P PS=10.88U
+ PD=10.88U
.ENDS B04_OTA_bias_ratio_5
