* Extracted by KLayout with GF180MCU LVS runset on : 02/09/2026 13:18

.SUBCKT B04_AFE_top Venvelope Vbpf VDD Vin Cap2 Cap1 Cap0 Vthreshold Vout GND
X$101 \$9 \$17 VDD Venvelope \$15 Vbpf \$28 GND B04_buffer_out
X$126 \$17 \$9 VDD GND B04_BMR
X$127 Cap0 Cap1 Cap2 \$9 \$29 \$17 VDD \$28 \$78 GND B04_BPF4
X$139 \$17 \$9 VDD \$29 GND B04_VDD05
X$159 \$15 \$9 VDD \$28 GND B04_envelope
X$160 Vin \$26 VDD \$17 GND B04_LNAv2
X$605 \$17 Vout Vthreshold \$15 VDD GND B04_comparator
X$729 \$26 \$78 \$29 B04_coupling
.ENDS B04_AFE_top

.SUBCKT B04_buffer_out VbiasN VbiasP VDD Venvelope Vinenvelope Vbpf Vinbpf GND
X$1 \$8 VbiasN VDD \$10 \$4 \$3 VbiasP GND B04_OTA_bias_ratio_5
X$2 \$4 \$3 Venvelope VDD Venvelope Vinenvelope \$8 \$10 GND B04_OTA
X$3 \$4 \$3 Vbpf VDD Vbpf Vinbpf \$8 \$10 GND B04_OTA
.ENDS B04_buffer_out

.SUBCKT B04_comparator VBIASP Q_BAR INN INP VDD GND
M$1 \$4 VBIASP VDD VDD pfet_03v3 L=4U W=4U AS=1.76P AD=1.76P PS=8.88U PD=8.88U
M$2 \$3 \$8 VDD VDD pfet_03v3 L=0.28U W=1.5U AS=0.6509P AD=0.6509P PS=3.88U
+ PD=3.88U
M$3 \$8 \$13 VDD VDD pfet_03v3 L=0.28U W=1.5U AS=0.6509P AD=0.6509P PS=3.88U
+ PD=3.88U
M$4 \$13 \$13 VDD VDD pfet_03v3 L=0.28U W=1.5U AS=0.6509P AD=0.6509P PS=3.88U
+ PD=3.88U
M$5 VDD \$8 \$8 VDD pfet_03v3 L=0.28U W=1.5U AS=0.6509P AD=0.6509P PS=3.88U
+ PD=3.88U
M$6 VDD \$8 \$13 VDD pfet_03v3 L=0.28U W=1.5U AS=0.6509P AD=0.6509P PS=3.88U
+ PD=3.88U
M$7 VDD \$13 Q_BAR VDD pfet_03v3 L=0.28U W=1.5U AS=0.6509P AD=0.6509P PS=3.88U
+ PD=3.88U
M$8 \$13 INP \$5 GND nfet_03v3 L=0.28U W=2U AS=0.86765P AD=0.86765P PS=4.88U
+ PD=4.88U
M$9 \$5 INN \$8 GND nfet_03v3 L=0.28U W=2U AS=0.86765P AD=0.86765P PS=4.88U
+ PD=4.88U
M$10 \$4 \$4 GND GND nfet_03v3 L=0.56U W=1U AS=0.44P AD=0.44P PS=2.88U PD=2.88U
M$11 \$5 \$4 GND GND nfet_03v3 L=0.56U W=1U AS=0.44P AD=0.44P PS=2.88U PD=2.88U
M$12 Q_BAR \$3 GND GND nfet_03v3 L=0.56U W=1U AS=0.44P AD=0.44P PS=2.88U
+ PD=2.88U
M$13 \$3 \$3 GND GND nfet_03v3 L=0.56U W=1U AS=0.44P AD=0.44P PS=2.88U PD=2.88U
.ENDS B04_comparator

.SUBCKT B04_envelope Vout VbiasN VDD Vin GND
C$1 GND Vout 2e-11 cap_mim_2f0fF A=10000P P=4000U
M$101 Vout Vin VDD GND nfet_03v3 L=1U W=2U AS=0.88P AD=0.88P PS=4.88U PD=4.88U
M$102 \$206 VbiasN Vout GND nfet_03v3 L=4U W=0.5U AS=0.22P AD=0.22P PS=1.88U
+ PD=1.88U
M$103 \$191 VbiasN \$192 GND nfet_03v3 L=4U W=0.5U AS=0.22P AD=0.22P PS=1.88U
+ PD=1.88U
M$104 GND VbiasN \$192 GND nfet_03v3 L=4U W=0.5U AS=0.22P AD=0.22P PS=1.88U
+ PD=1.88U
M$105 \$191 VbiasN \$207 GND nfet_03v3 L=4U W=0.5U AS=0.22P AD=0.22P PS=1.88U
+ PD=1.88U
M$106 \$206 VbiasN \$207 GND nfet_03v3 L=4U W=0.5U AS=0.22P AD=0.22P PS=1.88U
+ PD=1.88U
.ENDS B04_envelope

.SUBCKT B04_BPF4 Cap0 Cap1 Cap2 VbiasN VDD05 VbiasP VDD Vout Vin GND
X$137 \$774 \$763 Vout VDD \$765 \$51 \$764 \$773 GND B04_OTA
X$138 \$755 \$745 \$63 VDD VDD05 \$51 \$756 \$761 GND B04_OTA
X$139 \$753 \$744 \$51 VDD \$51 VDD05 \$754 \$760 GND B04_OTA
X$140 \$757 \$746 \$51 VDD \$63 VDD05 \$758 \$762 GND B04_OTA
X$141 \$751 \$743 \$51 VDD VDD05 \$821 \$752 \$759 GND B04_OTA
X$372 \$752 VbiasN VDD \$751 \$759 \$743 VbiasP GND B04_OTA_bias_ratio_025
X$373 \$756 VbiasN VDD \$755 \$761 \$745 VbiasP GND B04_OTA_bias_ratio_04
X$374 \$758 VbiasN VDD \$757 \$762 \$746 VbiasP GND B04_OTA_bias_ratio_04
X$375 \$754 VbiasN VDD \$753 \$760 \$744 VbiasP GND B04_OTA_bias_ratio_025
X$376 \$764 VbiasN VDD \$773 \$774 \$763 VbiasP GND B04_OTA_bias_ratio_5
X$401 \$753 \$744 \$821 VDD \$821 VDD05 \$754 \$760 GND B04_OTA
X$402 \$757 \$746 \$821 VDD \$852 VDD05 \$758 \$762 GND B04_OTA
X$403 \$751 \$743 \$821 VDD VDD05 Vin \$752 \$759 GND B04_OTA
X$404 \$755 \$745 \$852 VDD VDD05 \$821 \$756 \$761 GND B04_OTA
C$1 GND GND 3.84e-11 cap_mim_2f0fF A=19200P P=7680U
C$30 \$52 \$51 8e-12 cap_mim_2f0fF A=4000P P=1600U
C$34 \$64 \$63 2e-12 cap_mim_2f0fF A=1000P P=400U
C$59 \$95 \$63 4e-12 cap_mim_2f0fF A=2000P P=800U
C$106 GND \$63 1e-11 cap_mim_2f0fF A=5000P P=2000U
C$128 GND \$51 1e-11 cap_mim_2f0fF A=5000P P=2000U
C$226 \$437 \$63 8e-12 cap_mim_2f0fF A=4000P P=1600U
C$248 \$472 \$51 4e-12 cap_mim_2f0fF A=2000P P=800U
C$297 \$573 \$51 2e-12 cap_mim_2f0fF A=1000P P=400U
C$328 \$765 VDD05 4e-12 cap_mim_2f0fF A=2000P P=800U
C$335 \$765 Vout 2e-13 cap_mim_2f0fF A=100P P=40U
C$388 \$864 \$821 2e-12 cap_mim_2f0fF A=1000P P=400U
C$390 \$874 \$852 8e-12 cap_mim_2f0fF A=4000P P=1600U
C$413 \$865 \$821 4e-12 cap_mim_2f0fF A=2000P P=800U
C$461 GND \$821 1e-11 cap_mim_2f0fF A=5000P P=2000U
C$484 GND \$852 1e-11 cap_mim_2f0fF A=5000P P=2000U
C$589 \$866 \$821 8e-12 cap_mim_2f0fF A=4000P P=1600U
C$608 \$873 \$852 4e-12 cap_mim_2f0fF A=2000P P=800U
C$654 \$871 \$852 2e-12 cap_mim_2f0fF A=1000P P=400U
M$694 Vout Vout \$765 \$765 pfet_03v3 L=4U W=0.5U AS=0.22P AD=0.22P PS=1.88U
+ PD=1.88U
M$695 Vout \$765 \$765 Vout pfet_03v3 L=4U W=0.5U AS=0.22P AD=0.22P PS=1.88U
+ PD=1.88U
M$696 GND Cap2 \$52 GND nfet_03v3 L=1U W=0.5U AS=0.22P AD=0.22P PS=1.88U
+ PD=1.88U
M$697 GND Cap0 \$64 GND nfet_03v3 L=1U W=0.5U AS=0.22P AD=0.22P PS=1.88U
+ PD=1.88U
M$698 GND Cap1 \$95 GND nfet_03v3 L=1U W=0.5U AS=0.22P AD=0.22P PS=1.88U
+ PD=1.88U
M$699 GND Cap2 \$437 GND nfet_03v3 L=1U W=0.5U AS=0.22P AD=0.22P PS=1.88U
+ PD=1.88U
M$700 GND Cap1 \$472 GND nfet_03v3 L=1U W=0.5U AS=0.22P AD=0.22P PS=1.88U
+ PD=1.88U
M$701 GND Cap0 \$573 GND nfet_03v3 L=1U W=0.5U AS=0.22P AD=0.22P PS=1.88U
+ PD=1.88U
M$702 GND Cap0 \$871 GND nfet_03v3 L=1U W=0.5U AS=0.22P AD=0.22P PS=1.88U
+ PD=1.88U
M$703 GND Cap0 \$864 GND nfet_03v3 L=1U W=0.5U AS=0.22P AD=0.22P PS=1.88U
+ PD=1.88U
M$704 GND Cap1 \$873 GND nfet_03v3 L=1U W=0.5U AS=0.22P AD=0.22P PS=1.88U
+ PD=1.88U
M$705 GND Cap1 \$865 GND nfet_03v3 L=1U W=0.5U AS=0.22P AD=0.22P PS=1.88U
+ PD=1.88U
M$706 GND Cap2 \$874 GND nfet_03v3 L=1U W=0.5U AS=0.22P AD=0.22P PS=1.88U
+ PD=1.88U
M$707 GND Cap2 \$866 GND nfet_03v3 L=1U W=0.5U AS=0.22P AD=0.22P PS=1.88U
+ PD=1.88U
.ENDS B04_BPF4

.SUBCKT B04_coupling Vin Vout VDD05
C$1 Vout Vin 4e-12 cap_mim_2f0fF A=2000P P=800U
M$21 VDD05 Vout Vout VDD05 pfet_03v3 L=4U W=0.5U AS=0.22P AD=0.22P PS=1.88U
+ PD=1.88U
M$22 VDD05 VDD05 Vout Vout pfet_03v3 L=4U W=0.5U AS=0.22P AD=0.22P PS=1.88U
+ PD=1.88U
.ENDS B04_coupling

.SUBCKT B04_LNAv2 Vin Vout VDD VbiasP GND
C$1 \$8 Vin 4e-12 cap_mim_2f0fF A=2000P P=800U
C$20 Vout \$8 2e-13 cap_mim_2f0fF A=100P P=40U
M$22 Vout VbiasP VDD VDD pfet_03v3 L=4U W=40U AS=17.6P AD=17.6P PS=115.2U
+ PD=115.2U
M$62 Vout Vout \$8 \$8 pfet_03v3 L=20U W=1U AS=0.44P AD=0.44P PS=2.88U PD=2.88U
M$63 Vout \$8 \$8 Vout pfet_03v3 L=20U W=1U AS=0.44P AD=0.44P PS=2.88U PD=2.88U
M$64 Vout \$8 GND GND nfet_03v3 L=1U W=400U AS=111.2P AD=111.2P PS=495.6U
+ PD=495.6U
.ENDS B04_LNAv2

.SUBCKT B04_BMR VbiasP VbiasN VDD GND
X$3 VbiasN \$67 VbiasN VbiasP VDD GND B04_diff_amp
C$1 VbiasN VbiasP 4e-12 cap_mim_2f0fF A=2000P P=800U
M$21 \$69 VbiasN GND GND nfet_03v3 L=1U W=20U AS=8.8P AD=8.8P PS=40.88U
+ PD=40.88U
R$22 GND \$27 GND 410000 ppolyf_u_1k L=820U W=2U
M$42 VbiasP \$69 VbiasN GND nfet_03v3 L=1U W=1U AS=0.44P AD=0.44P PS=2.88U
+ PD=2.88U
M$43 \$78 \$69 \$69 VDD pfet_03v3 L=40U W=0.5U AS=0.22P AD=0.22P PS=1.88U
+ PD=1.88U
M$44 VDD \$80 \$80 VDD pfet_03v3 L=40U W=0.5U AS=0.22P AD=0.22P PS=1.88U
+ PD=1.88U
M$45 \$78 \$78 \$80 VDD pfet_03v3 L=40U W=0.5U AS=0.22P AD=0.22P PS=1.88U
+ PD=1.88U
M$46 VDD VbiasP VbiasN VDD pfet_03v3 L=4U W=2U AS=0.88P AD=0.88P PS=5.76U
+ PD=5.76U
M$48 \$67 VbiasP VDD VDD pfet_03v3 L=4U W=2U AS=0.88P AD=0.88P PS=5.76U PD=5.76U
M$50 VDD VDD VDD VDD pfet_03v3 L=4U W=2U AS=0.88P AD=0.88P PS=5.76U PD=5.76U
M$52 GND VbiasN VbiasN GND nfet_03v3 L=4U W=10U AS=4.4P AD=4.4P PS=20.88U
+ PD=20.88U
M$53 GND GND GND GND nfet_03v3 L=4U W=20U AS=8.8P AD=8.8P PS=41.76U PD=41.76U
M$55 \$67 VbiasN \$27 GND nfet_03v3 L=4U W=40U AS=14P AD=14P PS=62.8U PD=62.8U
.ENDS B04_BMR

.SUBCKT B04_VDD05 VbiasP VbiasN VDD Vout GND
X$1 \$17 VbiasN VDD \$16 \$31 \$15 VbiasP GND B04_OTA_bias_ratio_5
X$3 \$31 \$15 Vout VDD Vout \$20 \$17 \$16 GND B04_OTA
R$1 GND GND GND 3750 ppolyf_u_1k L=30U W=8U
R$12 GND \$20 GND 300000 ppolyf_u_1k L=600U W=2U
R$43 VDD \$20 GND 300000 ppolyf_u_1k L=600U W=2U
.ENDS B04_VDD05

.SUBCKT B04_OTA_bias_ratio_04 Vbias3 VbiasN VDD Vbias1 Vbias0 Vbias2 VbiasP GND
M$1 Vbias2 VbiasP VDD VDD pfet_03v3 L=4U W=2U AS=0.88P AD=0.88P PS=4.88U
+ PD=4.88U
M$2 Vbias3 VbiasN GND GND nfet_03v3 L=4U W=4U AS=1.76P AD=1.76P PS=8.88U
+ PD=8.88U
M$3 \$9 Vbias1 GND GND nfet_03v3 L=4U W=1U AS=0.44P AD=0.44P PS=2.88U PD=2.88U
M$4 Vbias1 Vbias2 \$9 GND nfet_03v3 L=4U W=1U AS=0.44P AD=0.44P PS=2.88U
+ PD=2.88U
M$5 Vbias3 VDD Vbias0 GND nfet_03v3 L=4U W=10U AS=4.4P AD=4.4P PS=20.88U
+ PD=20.88U
M$6 Vbias0 Vbias3 \$13 VDD pfet_03v3 L=4U W=5U AS=2.2P AD=2.2P PS=10.88U
+ PD=10.88U
M$7 \$13 Vbias0 VDD VDD pfet_03v3 L=4U W=5U AS=2.2P AD=2.2P PS=10.88U PD=10.88U
M$8 Vbias1 GND Vbias2 VDD pfet_03v3 L=4U W=5U AS=2.2P AD=2.2P PS=10.88U
+ PD=10.88U
.ENDS B04_OTA_bias_ratio_04

.SUBCKT B04_OTA_bias_ratio_025 Vbias3 VbiasN VDD Vbias1 Vbias0 Vbias2 VbiasP GND
M$1 Vbias2 VbiasP VDD VDD pfet_03v3 L=4U W=1.25U AS=0.55P AD=0.55P PS=3.38U
+ PD=3.38U
M$2 Vbias3 VbiasN GND GND nfet_03v3 L=4U W=2.5U AS=1.1P AD=1.1P PS=5.88U
+ PD=5.88U
M$3 Vbias1 Vbias2 \$10 GND nfet_03v3 L=4U W=1U AS=0.44P AD=0.44P PS=2.88U
+ PD=2.88U
M$4 \$10 Vbias1 GND GND nfet_03v3 L=4U W=1U AS=0.44P AD=0.44P PS=2.88U PD=2.88U
M$5 Vbias3 VDD Vbias0 GND nfet_03v3 L=4U W=10U AS=4.4P AD=4.4P PS=20.88U
+ PD=20.88U
M$6 Vbias0 Vbias3 \$14 VDD pfet_03v3 L=4U W=5U AS=2.2P AD=2.2P PS=10.88U
+ PD=10.88U
M$7 \$14 Vbias0 VDD VDD pfet_03v3 L=4U W=5U AS=2.2P AD=2.2P PS=10.88U PD=10.88U
M$8 Vbias1 GND Vbias2 VDD pfet_03v3 L=4U W=5U AS=2.2P AD=2.2P PS=10.88U
+ PD=10.88U
.ENDS B04_OTA_bias_ratio_025

.SUBCKT B04_diff_amp Vbias V+ V\x2d Vo VDD GND
M$1 VDD \$7 \$7 VDD pfet_03v3 L=4U W=13U AS=5.72P AD=5.72P PS=27.76U PD=27.76U
M$3 VDD \$7 Vo VDD pfet_03v3 L=4U W=13U AS=5.72P AD=5.72P PS=27.76U PD=27.76U
M$5 VDD VDD VDD VDD pfet_03v3 L=4U W=13U AS=5.72P AD=5.72P PS=27.76U PD=27.76U
M$7 GND Vbias \$4 GND nfet_03v3 L=4U W=2.2U AS=0.968P AD=0.968P PS=5.28U
+ PD=5.28U
M$8 \$7 V+ \$4 GND nfet_03v3 L=4U W=1.1U AS=0.484P AD=0.484P PS=3.96U PD=3.96U
M$10 \$4 V\x2d Vo GND nfet_03v3 L=4U W=1.1U AS=0.484P AD=0.484P PS=3.96U
+ PD=3.96U
M$12 GND GND GND GND nfet_03v3 L=4U W=1.1U AS=0.484P AD=0.484P PS=3.96U PD=3.96U
.ENDS B04_diff_amp

.SUBCKT B04_OTA Vbias1 Vbias2 Vout VDD Vin\x2d Vin+ Vbias3 Vbias0 GND
M$1 \$16 Vbias0 VDD VDD pfet_03v3 L=4U W=5U AS=1.75P AD=1.75P PS=8.9U PD=8.9U
M$3 Vout Vbias3 \$19 VDD pfet_03v3 L=4U W=5U AS=2.2P AD=2.2P PS=11.76U PD=11.76U
M$5 VDD \$11 \$19 VDD pfet_03v3 L=4U W=5U AS=2.2P AD=2.2P PS=11.76U PD=11.76U
M$6 VDD \$11 \$21 VDD pfet_03v3 L=4U W=5U AS=2.2P AD=2.2P PS=11.76U PD=11.76U
M$9 \$21 Vbias3 \$11 VDD pfet_03v3 L=4U W=5U AS=2.2P AD=2.2P PS=11.76U PD=11.76U
M$11 VDD VDD VDD VDD pfet_03v3 L=4U W=10U AS=4.4P AD=4.4P PS=23.52U PD=23.52U
M$15 \$5 Vin\x2d \$16 VDD pfet_03v3 L=1U W=2U AS=0.61P AD=0.61P PS=4.94U
+ PD=4.94U
M$19 \$9 Vin+ \$16 VDD pfet_03v3 L=1U W=2U AS=0.61P AD=0.61P PS=4.94U PD=4.94U
M$23 \$3 Vin+ \$16 VDD pfet_03v3 L=1U W=2U AS=0.61P AD=0.61P PS=4.94U PD=4.94U
M$27 \$4 Vin\x2d \$16 VDD pfet_03v3 L=1U W=2U AS=0.61P AD=0.61P PS=4.94U
+ PD=4.94U
M$31 VDD VDD VDD VDD pfet_03v3 L=1U W=2U AS=0.88P AD=0.88P PS=7.52U PD=7.52U
M$35 \$2 Vbias2 \$5 GND nfet_03v3 L=1U W=2U AS=0.88P AD=0.88P PS=5.76U PD=5.76U
M$36 \$9 Vbias2 \$7 GND nfet_03v3 L=1U W=2U AS=0.88P AD=0.88P PS=5.76U PD=5.76U
M$37 GND GND GND GND nfet_03v3 L=1U W=4U AS=1.76P AD=1.76P PS=11.52U PD=11.52U
M$43 GND \$5 \$2 GND nfet_03v3 L=4U W=1U AS=0.44P AD=0.44P PS=3.76U PD=3.76U
M$44 \$3 Vbias1 GND GND nfet_03v3 L=4U W=1U AS=0.44P AD=0.44P PS=3.76U PD=3.76U
M$45 \$3 \$5 GND GND nfet_03v3 L=4U W=1U AS=0.44P AD=0.44P PS=3.76U PD=3.76U
M$46 GND \$9 \$4 GND nfet_03v3 L=4U W=1U AS=0.44P AD=0.44P PS=3.76U PD=3.76U
M$47 GND Vbias1 \$4 GND nfet_03v3 L=4U W=1U AS=0.44P AD=0.44P PS=3.76U PD=3.76U
M$48 \$7 \$9 GND GND nfet_03v3 L=4U W=1U AS=0.44P AD=0.44P PS=3.76U PD=3.76U
M$49 GND GND GND GND nfet_03v3 L=4U W=3U AS=1.32P AD=1.32P PS=11.28U PD=11.28U
M$52 \$3 Vbias2 \$11 GND nfet_03v3 L=4U W=1U AS=0.44P AD=0.44P PS=3.76U PD=3.76U
M$58 \$4 Vbias2 Vout GND nfet_03v3 L=4U W=1U AS=0.44P AD=0.44P PS=3.76U PD=3.76U
.ENDS B04_OTA

.SUBCKT B04_OTA_bias_ratio_5 Vbias3 VbiasN VDD Vbias0 Vbias1 Vbias2 VbiasP GND
M$1 Vbias2 VbiasP VDD VDD pfet_03v3 L=4U W=25U AS=11P AD=11P PS=50.88U PD=50.88U
M$2 Vbias3 VbiasN GND GND nfet_03v3 L=4U W=50U AS=22P AD=22P PS=100.88U
+ PD=100.88U
M$3 Vbias1 Vbias2 \$10 GND nfet_03v3 L=4U W=1U AS=0.44P AD=0.44P PS=2.88U
+ PD=2.88U
M$4 \$10 Vbias1 GND GND nfet_03v3 L=4U W=1U AS=0.44P AD=0.44P PS=2.88U PD=2.88U
M$5 Vbias3 VDD Vbias0 GND nfet_03v3 L=4U W=10U AS=4.4P AD=4.4P PS=20.88U
+ PD=20.88U
M$6 Vbias0 Vbias3 \$15 VDD pfet_03v3 L=4U W=5U AS=2.2P AD=2.2P PS=10.88U
+ PD=10.88U
M$7 \$15 Vbias0 VDD VDD pfet_03v3 L=4U W=5U AS=2.2P AD=2.2P PS=10.88U PD=10.88U
M$8 Vbias1 GND Vbias2 VDD pfet_03v3 L=4U W=5U AS=2.2P AD=2.2P PS=10.88U
+ PD=10.88U
.ENDS B04_OTA_bias_ratio_5
