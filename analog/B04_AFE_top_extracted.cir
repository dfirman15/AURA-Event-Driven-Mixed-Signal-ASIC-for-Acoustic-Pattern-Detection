* Extracted by KLayout with GF180MCU LVS runset on : 03/09/2026 16:16

.SUBCKT B04_AFE_top Venvelope Vbpf VDD Vin Cap2 Cap1 Cap0 Vthreshold Vout GND
X$101 \$9 \$17 VDD Venvelope \$15 Vbpf \$28 GND B04_buffer_out
X$126 \$17 \$9 VDD GND B04_BMR
X$127 Cap0 Cap1 Cap2 VDD \$9 \$29 \$17 \$28 \$78 GND B04_BPF4
X$139 \$17 \$9 VDD \$29 GND B04_VDD05
X$159 \$15 \$9 VDD \$28 GND B04_envelope
X$160 Vin \$26 VDD \$17 GND B04_LNAv2
X$605 \$17 Vout Vthreshold \$15 VDD GND B04_comparator
X$729 \$26 \$78 \$29 B04_coupling
.ENDS B04_AFE_top

.SUBCKT B04_buffer_out VbiasN VbiasP VDD Venvelope Vinenvelope Vbpf Vinbpf GND
X$1 \$8 VbiasN VDD \$10 \$4 \$3 VbiasP GND B04_OTA_bias_ratio_5
X$2 \$4 \$3 Venvelope VDD Venvelope Vinenvelope \$8 \$10 GND B04_OTA
X$3 \$4 \$3 Vbpf VDD Vbpf Vinbpf \$8 \$10 GND B04_OTA
.ENDS B04_buffer_out

.SUBCKT B04_comparator VBIASP Q_BAR INN INP VDD GND
M$1 \$4 VBIASP VDD VDD pfet_03v3 L=4U W=4U AS=1.76P AD=1.76P PS=8.88U PD=8.88U
M$2 \$3 \$8 VDD VDD pfet_03v3 L=0.28U W=1.5U AS=0.6509P AD=0.6509P PS=3.88U
+ PD=3.88U
M$3 \$8 \$13 VDD VDD pfet_03v3 L=0.28U W=1.5U AS=0.6509P AD=0.6509P PS=3.88U
+ PD=3.88U
M$4 \$13 \$13 VDD VDD pfet_03v3 L=0.28U W=1.5U AS=0.6509P AD=0.6509P PS=3.88U
+ PD=3.88U
M$5 VDD \$8 \$8 VDD pfet_03v3 L=0.28U W=1.5U AS=0.6509P AD=0.6509P PS=3.88U
+ PD=3.88U
M$6 VDD \$8 \$13 VDD pfet_03v3 L=0.28U W=1.5U AS=0.6509P AD=0.6509P PS=3.88U
+ PD=3.88U
M$7 VDD \$13 Q_BAR VDD pfet_03v3 L=0.28U W=1.5U AS=0.6509P AD=0.6509P PS=3.88U
+ PD=3.88U
M$8 \$13 INP \$5 GND nfet_03v3 L=0.28U W=2U AS=0.86765P AD=0.86765P PS=4.88U
+ PD=4.88U
M$9 \$5 INN \$8 GND nfet_03v3 L=0.28U W=2U AS=0.86765P AD=0.86765P PS=4.88U
+ PD=4.88U
M$10 \$4 \$4 GND GND nfet_03v3 L=0.56U W=1U AS=0.44P AD=0.44P PS=2.88U PD=2.88U
M$11 \$5 \$4 GND GND nfet_03v3 L=0.56U W=1U AS=0.44P AD=0.44P PS=2.88U PD=2.88U
M$12 Q_BAR \$3 GND GND nfet_03v3 L=0.56U W=1U AS=0.44P AD=0.44P PS=2.88U
+ PD=2.88U
M$13 \$3 \$3 GND GND nfet_03v3 L=0.56U W=1U AS=0.44P AD=0.44P PS=2.88U PD=2.88U
.ENDS B04_comparator

.SUBCKT B04_envelope Vout VbiasN VDD Vin GND
D$1 Vout VDD diode_pd2nw_03v3 A=5P P=20U
C$6 GND Vout 2e-11 cap_mim_2f0fF A=10000P P=4000U
M$106 Vout Vin VDD GND nfet_03v3 L=1U W=2U AS=0.88P AD=0.88P PS=4.88U PD=4.88U
M$107 \$207 VbiasN Vout GND nfet_03v3 L=4U W=0.5U AS=0.22P AD=0.22P PS=1.88U
+ PD=1.88U
M$108 \$191 VbiasN \$192 GND nfet_03v3 L=4U W=0.5U AS=0.22P AD=0.22P PS=1.88U
+ PD=1.88U
M$109 GND VbiasN \$192 GND nfet_03v3 L=4U W=0.5U AS=0.22P AD=0.22P PS=1.88U
+ PD=1.88U
M$110 \$191 VbiasN \$206 GND nfet_03v3 L=4U W=0.5U AS=0.22P AD=0.22P PS=1.88U
+ PD=1.88U
M$111 \$207 VbiasN \$206 GND nfet_03v3 L=4U W=0.5U AS=0.22P AD=0.22P PS=1.88U
+ PD=1.88U
D$112 GND Vout diode_nd2ps_03v3 A=5P P=20U
.ENDS B04_envelope

.SUBCKT B04_BPF4 Cap0 Cap1 Cap2 VDD VbiasN VDD05 VbiasP Vout Vin GND
X$137 \$779 \$768 Vout VDD \$770 \$51 \$769 \$778 GND B04_OTA
X$138 \$760 \$750 \$63 VDD VDD05 \$51 \$761 \$766 GND B04_OTA
X$139 \$758 \$749 \$51 VDD \$51 VDD05 \$759 \$765 GND B04_OTA
X$140 \$762 \$752 \$51 VDD \$63 VDD05 \$763 \$767 GND B04_OTA
X$141 \$756 \$748 \$51 VDD VDD05 \$826 \$757 \$764 GND B04_OTA
X$412 \$757 VbiasN VDD \$756 \$764 \$748 VbiasP GND B04_OTA_bias_ratio_025
X$413 \$761 VbiasN VDD \$760 \$766 \$750 VbiasP GND B04_OTA_bias_ratio_04
X$414 \$759 VbiasN VDD \$758 \$765 \$749 VbiasP GND B04_OTA_bias_ratio_025
X$415 \$763 VbiasN VDD \$762 \$767 \$752 VbiasP GND B04_OTA_bias_ratio_04
X$428 \$769 VbiasN VDD \$778 \$779 \$768 VbiasP GND B04_OTA_bias_ratio_5
X$429 \$758 \$749 \$826 VDD \$826 VDD05 \$759 \$765 GND B04_OTA
X$430 \$756 \$748 \$826 VDD VDD05 Vin \$757 \$764 GND B04_OTA
X$431 \$760 \$750 \$857 VDD VDD05 \$826 \$761 \$766 GND B04_OTA
X$432 \$762 \$752 \$826 VDD \$857 VDD05 \$763 \$767 GND B04_OTA
D$1 \$63 VDD diode_pd2nw_03v3 A=5P P=20U
D$6 \$857 VDD diode_pd2nw_03v3 A=5P P=20U
C$11 GND GND 3.84e-11 cap_mim_2f0fF A=19200P P=7680U
C$40 \$52 \$51 8e-12 cap_mim_2f0fF A=4000P P=1600U
C$44 \$64 \$63 2e-12 cap_mim_2f0fF A=1000P P=400U
C$69 \$95 \$63 4e-12 cap_mim_2f0fF A=2000P P=800U
C$116 GND \$63 1e-11 cap_mim_2f0fF A=5000P P=2000U
C$138 GND \$51 1e-11 cap_mim_2f0fF A=5000P P=2000U
C$236 \$437 \$63 8e-12 cap_mim_2f0fF A=4000P P=1600U
C$258 \$472 \$51 4e-12 cap_mim_2f0fF A=2000P P=800U
C$307 \$573 \$51 2e-12 cap_mim_2f0fF A=1000P P=400U
C$338 \$770 VDD05 4e-12 cap_mim_2f0fF A=2000P P=800U
C$345 \$770 Vout 2e-13 cap_mim_2f0fF A=100P P=40U
C$397 \$869 \$826 2e-12 cap_mim_2f0fF A=1000P P=400U
C$400 \$879 \$857 8e-12 cap_mim_2f0fF A=4000P P=1600U
C$423 \$870 \$826 4e-12 cap_mim_2f0fF A=2000P P=800U
C$471 GND \$826 1e-11 cap_mim_2f0fF A=5000P P=2000U
C$494 GND \$857 1e-11 cap_mim_2f0fF A=5000P P=2000U
C$599 \$871 \$826 8e-12 cap_mim_2f0fF A=4000P P=1600U
C$618 \$878 \$857 4e-12 cap_mim_2f0fF A=2000P P=800U
C$664 \$876 \$857 2e-12 cap_mim_2f0fF A=1000P P=400U
M$704 Vout Vout \$770 \$770 pfet_03v3 L=4U W=0.5U AS=0.22P AD=0.22P PS=1.88U
+ PD=1.88U
M$705 Vout \$770 \$770 Vout pfet_03v3 L=4U W=0.5U AS=0.22P AD=0.22P PS=1.88U
+ PD=1.88U
M$706 GND Cap2 \$52 GND nfet_03v3 L=1U W=0.5U AS=0.22P AD=0.22P PS=1.88U
+ PD=1.88U
M$707 GND Cap0 \$64 GND nfet_03v3 L=1U W=0.5U AS=0.22P AD=0.22P PS=1.88U
+ PD=1.88U
M$708 GND Cap1 \$95 GND nfet_03v3 L=1U W=0.5U AS=0.22P AD=0.22P PS=1.88U
+ PD=1.88U
M$709 GND Cap2 \$437 GND nfet_03v3 L=1U W=0.5U AS=0.22P AD=0.22P PS=1.88U
+ PD=1.88U
M$710 GND Cap1 \$472 GND nfet_03v3 L=1U W=0.5U AS=0.22P AD=0.22P PS=1.88U
+ PD=1.88U
M$711 GND Cap0 \$573 GND nfet_03v3 L=1U W=0.5U AS=0.22P AD=0.22P PS=1.88U
+ PD=1.88U
M$712 GND Cap0 \$876 GND nfet_03v3 L=1U W=0.5U AS=0.22P AD=0.22P PS=1.88U
+ PD=1.88U
M$713 GND Cap0 \$869 GND nfet_03v3 L=1U W=0.5U AS=0.22P AD=0.22P PS=1.88U
+ PD=1.88U
M$714 GND Cap1 \$878 GND nfet_03v3 L=1U W=0.5U AS=0.22P AD=0.22P PS=1.88U
+ PD=1.88U
M$715 GND Cap1 \$870 GND nfet_03v3 L=1U W=0.5U AS=0.22P AD=0.22P PS=1.88U
+ PD=1.88U
M$716 GND Cap2 \$879 GND nfet_03v3 L=1U W=0.5U AS=0.22P AD=0.22P PS=1.88U
+ PD=1.88U
M$717 GND Cap2 \$871 GND nfet_03v3 L=1U W=0.5U AS=0.22P AD=0.22P PS=1.88U
+ PD=1.88U
D$718 GND \$63 diode_nd2ps_03v3 A=5P P=20U
D$723 GND \$857 diode_nd2ps_03v3 A=5P P=20U
.ENDS B04_BPF4

.SUBCKT B04_coupling Vin Vout VDD05
C$1 Vout Vin 4e-12 cap_mim_2f0fF A=2000P P=800U
M$21 VDD05 Vout Vout VDD05 pfet_03v3 L=4U W=0.5U AS=0.22P AD=0.22P PS=1.88U
+ PD=1.88U
M$22 VDD05 VDD05 Vout Vout pfet_03v3 L=4U W=0.5U AS=0.22P AD=0.22P PS=1.88U
+ PD=1.88U
.ENDS B04_coupling

.SUBCKT B04_LNAv2 Vin Vout VDD VbiasP GND
C$1 \$8 Vin 4e-12 cap_mim_2f0fF A=2000P P=800U
C$20 Vout \$8 2e-13 cap_mim_2f0fF A=100P P=40U
M$22 Vout VbiasP VDD VDD pfet_03v3 L=4U W=40U AS=17.6P AD=17.6P PS=115.2U
+ PD=115.2U
M$62 Vout Vout \$8 \$8 pfet_03v3 L=20U W=1U AS=0.44P AD=0.44P PS=2.88U PD=2.88U
M$63 Vout \$8 \$8 Vout pfet_03v3 L=20U W=1U AS=0.44P AD=0.44P PS=2.88U PD=2.88U
M$64 Vout \$8 GND GND nfet_03v3 L=1U W=400U AS=111.2P AD=111.2P PS=495.6U
+ PD=495.6U
.ENDS B04_LNAv2

.SUBCKT B04_BMR VbiasP VbiasN VDD GND
X$3 VbiasN \$67 VbiasN VbiasP VDD GND B04_diff_amp
C$1 VbiasN VbiasP 4e-12 cap_mim_2f0fF A=2000P P=800U
M$21 \$69 VbiasN GND GND nfet_03v3 L=1U W=20U AS=8.8P AD=8.8P PS=40.88U
+ PD=40.88U
R$32 GND \$27 GND 410000 ppolyf_u_1k L=820U W=2U
M$42 VbiasP \$69 VbiasN GND nfet_03v3 L=1U W=1U AS=0.44P AD=0.44P PS=2.88U
+ PD=2.88U
M$43 \$78 \$69 \$69 VDD pfet_03v3 L=40U W=0.5U AS=0.22P AD=0.22P PS=1.88U
+ PD=1.88U
M$44 VDD \$80 \$80 VDD pfet_03v3 L=40U W=0.5U AS=0.22P AD=0.22P PS=1.88U
+ PD=1.88U
M$45 \$78 \$78 \$80 VDD pfet_03v3 L=40U W=0.5U AS=0.22P AD=0.22P PS=1.88U
+ PD=1.88U
M$46 VDD VbiasP VbiasN VDD pfet_03v3 L=4U W=2U AS=0.88P AD=0.88P PS=5.76U
+ PD=5.76U
M$48 \$67 VbiasP VDD VDD pfet_03v3 L=4U W=2U AS=0.88P AD=0.88P PS=5.76U PD=5.76U
M$50 VDD VDD VDD VDD pfet_03v3 L=4U W=2U AS=0.88P AD=0.88P PS=5.76U PD=5.76U
M$52 GND VbiasN VbiasN GND nfet_03v3 L=4U W=10U AS=4.4P AD=4.4P PS=20.88U
+ PD=20.88U
M$53 GND GND GND GND nfet_03v3 L=4U W=20U AS=8.8P AD=8.8P PS=41.76U PD=41.76U
M$55 \$67 VbiasN \$27 GND nfet_03v3 L=4U W=40U AS=14P AD=14P PS=62.8U PD=62.8U
.ENDS B04_BMR

.SUBCKT B04_VDD05 VbiasP VbiasN VDD Vout GND
X$1 \$17 VbiasN VDD \$16 \$31 \$15 VbiasP GND B04_OTA_bias_ratio_5
X$3 \$31 \$15 Vout VDD Vout \$20 \$17 \$16 GND B04_OTA
R$1 GND GND GND 3750 ppolyf_u_1k L=30U W=8U
R$12 GND \$20 GND 300000 ppolyf_u_1k L=600U W=2U
R$43 VDD \$20 GND 300000 ppolyf_u_1k L=600U W=2U
.ENDS B04_VDD05

.SUBCKT B04_OTA_bias_ratio_04 Vbias3 VbiasN VDD Vbias1 Vbias0 Vbias2 VbiasP GND
M$1 Vbias2 VbiasP VDD VDD pfet_03v3 L=4U W=2U AS=0.88P AD=0.88P PS=4.88U
+ PD=4.88U
M$2 Vbias3 VbiasN GND GND nfet_03v3 L=4U W=4U AS=1.76P AD=1.76P PS=8.88U
+ PD=8.88U
M$3 \$9 Vbias1 GND GND nfet_03v3 L=4U W=1U AS=0.44P AD=0.44P PS=2.88U PD=2.88U
M$4 Vbias1 Vbias2 \$9 GND nfet_03v3 L=4U W=1U AS=0.44P AD=0.44P PS=2.88U
+ PD=2.88U
M$5 Vbias3 VDD Vbias0 GND nfet_03v3 L=4U W=10U AS=4.4P AD=4.4P PS=20.88U
+ PD=20.88U
M$6 Vbias0 Vbias3 \$13 VDD pfet_03v3 L=4U W=5U AS=2.2P AD=2.2P PS=10.88U
+ PD=10.88U
M$7 \$13 Vbias0 VDD VDD pfet_03v3 L=4U W=5U AS=2.2P AD=2.2P PS=10.88U PD=10.88U
M$8 Vbias1 GND Vbias2 VDD pfet_03v3 L=4U W=5U AS=2.2P AD=2.2P PS=10.88U
+ PD=10.88U
.ENDS B04_OTA_bias_ratio_04

.SUBCKT B04_OTA_bias_ratio_025 Vbias3 VbiasN VDD Vbias1 Vbias0 Vbias2 VbiasP GND
M$1 Vbias2 VbiasP VDD VDD pfet_03v3 L=4U W=1.25U AS=0.55P AD=0.55P PS=3.38U
+ PD=3.38U
M$2 Vbias3 VbiasN GND GND nfet_03v3 L=4U W=2.5U AS=1.1P AD=1.1P PS=5.88U
+ PD=5.88U
M$3 Vbias1 Vbias2 \$10 GND nfet_03v3 L=4U W=1U AS=0.44P AD=0.44P PS=2.88U
+ PD=2.88U
M$4 \$10 Vbias1 GND GND nfet_03v3 L=4U W=1U AS=0.44P AD=0.44P PS=2.88U PD=2.88U
M$5 Vbias3 VDD Vbias0 GND nfet_03v3 L=4U W=10U AS=4.4P AD=4.4P PS=20.88U
+ PD=20.88U
M$6 Vbias0 Vbias3 \$14 VDD pfet_03v3 L=4U W=5U AS=2.2P AD=2.2P PS=10.88U
+ PD=10.88U
M$7 \$14 Vbias0 VDD VDD pfet_03v3 L=4U W=5U AS=2.2P AD=2.2P PS=10.88U PD=10.88U
M$8 Vbias1 GND Vbias2 VDD pfet_03v3 L=4U W=5U AS=2.2P AD=2.2P PS=10.88U
+ PD=10.88U
.ENDS B04_OTA_bias_ratio_025

.SUBCKT B04_diff_amp Vbias V+ V\x2d Vo VDD GND
M$1 VDD \$7 \$7 VDD pfet_03v3 L=4U W=13U AS=5.72P AD=5.72P PS=27.76U PD=27.76U
M$3 VDD \$7 Vo VDD pfet_03v3 L=4U W=13U AS=5.72P AD=5.72P PS=27.76U PD=27.76U
M$5 VDD VDD VDD VDD pfet_03v3 L=4U W=13U AS=5.72P AD=5.72P PS=27.76U PD=27.76U
M$7 GND Vbias \$4 GND nfet_03v3 L=4U W=2.2U AS=0.968P AD=0.968P PS=5.28U
+ PD=5.28U
M$8 \$7 V+ \$4 GND nfet_03v3 L=4U W=1.1U AS=0.484P AD=0.484P PS=3.96U PD=3.96U
M$10 \$4 V\x2d Vo GND nfet_03v3 L=4U W=1.1U AS=0.484P AD=0.484P PS=3.96U
+ PD=3.96U
M$12 GND GND GND GND nfet_03v3 L=4U W=1.1U AS=0.484P AD=0.484P PS=3.96U PD=3.96U
.ENDS B04_diff_amp

.SUBCKT B04_OTA Vbias1 Vbias2 Vout VDD Vin\x2d Vin+ Vbias3 Vbias0 GND
M$1 \$16 Vbias0 VDD VDD pfet_03v3 L=4U W=5U AS=1.75P AD=1.75P PS=8.9U PD=8.9U
M$3 Vout Vbias3 \$19 VDD pfet_03v3 L=4U W=5U AS=2.2P AD=2.2P PS=11.76U PD=11.76U
M$5 VDD \$11 \$19 VDD pfet_03v3 L=4U W=5U AS=2.2P AD=2.2P PS=11.76U PD=11.76U
M$6 VDD \$11 \$21 VDD pfet_03v3 L=4U W=5U AS=2.2P AD=2.2P PS=11.76U PD=11.76U
M$9 \$21 Vbias3 \$11 VDD pfet_03v3 L=4U W=5U AS=2.2P AD=2.2P PS=11.76U PD=11.76U
M$11 VDD VDD VDD VDD pfet_03v3 L=4U W=10U AS=4.4P AD=4.4P PS=23.52U PD=23.52U
M$15 \$5 Vin\x2d \$16 VDD pfet_03v3 L=1U W=2U AS=0.61P AD=0.61P PS=4.94U
+ PD=4.94U
M$19 \$9 Vin+ \$16 VDD pfet_03v3 L=1U W=2U AS=0.61P AD=0.61P PS=4.94U PD=4.94U
M$23 \$3 Vin+ \$16 VDD pfet_03v3 L=1U W=2U AS=0.61P AD=0.61P PS=4.94U PD=4.94U
M$27 \$4 Vin\x2d \$16 VDD pfet_03v3 L=1U W=2U AS=0.61P AD=0.61P PS=4.94U
+ PD=4.94U
M$31 VDD VDD VDD VDD pfet_03v3 L=1U W=2U AS=0.88P AD=0.88P PS=7.52U PD=7.52U
M$35 \$2 Vbias2 \$5 GND nfet_03v3 L=1U W=2U AS=0.88P AD=0.88P PS=5.76U PD=5.76U
M$36 \$9 Vbias2 \$7 GND nfet_03v3 L=1U W=2U AS=0.88P AD=0.88P PS=5.76U PD=5.76U
M$37 GND GND GND GND nfet_03v3 L=1U W=4U AS=1.76P AD=1.76P PS=11.52U PD=11.52U
M$43 GND \$5 \$2 GND nfet_03v3 L=4U W=1U AS=0.44P AD=0.44P PS=3.76U PD=3.76U
M$44 \$3 Vbias1 GND GND nfet_03v3 L=4U W=1U AS=0.44P AD=0.44P PS=3.76U PD=3.76U
M$45 \$3 \$5 GND GND nfet_03v3 L=4U W=1U AS=0.44P AD=0.44P PS=3.76U PD=3.76U
M$46 GND \$9 \$4 GND nfet_03v3 L=4U W=1U AS=0.44P AD=0.44P PS=3.76U PD=3.76U
M$47 GND Vbias1 \$4 GND nfet_03v3 L=4U W=1U AS=0.44P AD=0.44P PS=3.76U PD=3.76U
M$48 \$7 \$9 GND GND nfet_03v3 L=4U W=1U AS=0.44P AD=0.44P PS=3.76U PD=3.76U
M$49 GND GND GND GND nfet_03v3 L=4U W=3U AS=1.32P AD=1.32P PS=11.28U PD=11.28U
M$52 \$3 Vbias2 \$11 GND nfet_03v3 L=4U W=1U AS=0.44P AD=0.44P PS=3.76U PD=3.76U
M$58 \$4 Vbias2 Vout GND nfet_03v3 L=4U W=1U AS=0.44P AD=0.44P PS=3.76U PD=3.76U
.ENDS B04_OTA

.SUBCKT B04_OTA_bias_ratio_5 Vbias3 VbiasN VDD Vbias0 Vbias1 Vbias2 VbiasP GND
M$1 Vbias2 VbiasP VDD VDD pfet_03v3 L=4U W=25U AS=11P AD=11P PS=50.88U PD=50.88U
M$2 Vbias3 VbiasN GND GND nfet_03v3 L=4U W=50U AS=22P AD=22P PS=100.88U
+ PD=100.88U
M$3 \$10 Vbias1 GND GND nfet_03v3 L=4U W=1U AS=0.44P AD=0.44P PS=2.88U PD=2.88U
M$4 Vbias1 Vbias2 \$10 GND nfet_03v3 L=4U W=1U AS=0.44P AD=0.44P PS=2.88U
+ PD=2.88U
M$5 Vbias3 VDD Vbias0 GND nfet_03v3 L=4U W=10U AS=4.4P AD=4.4P PS=20.88U
+ PD=20.88U
M$6 Vbias0 Vbias3 \$15 VDD pfet_03v3 L=4U W=5U AS=2.2P AD=2.2P PS=10.88U
+ PD=10.88U
M$7 \$15 Vbias0 VDD VDD pfet_03v3 L=4U W=5U AS=2.2P AD=2.2P PS=10.88U PD=10.88U
M$8 Vbias1 GND Vbias2 VDD pfet_03v3 L=4U W=5U AS=2.2P AD=2.2P PS=10.88U
+ PD=10.88U
.ENDS B04_OTA_bias_ratio_5
