* Extracted by KLayout with GF180MCU LVS runset on : 11/08/2026 15:58

.SUBCKT B04_BPF4 VbiasN VbiasP VDD Vin SUB
X$73 SUB \$222 \$223 VDD \$235 \$6 \$7 \$224 \$227 SUB B04_OTA
X$74 SUB \$218 \$220 VDD \$7 \$235 \$6 \$221 \$230 SUB B04_OTA
X$139 SUB \$213 \$214 VDD \$239 \$235 \$7 \$215 \$228 SUB B04_OTA
X$140 SUB \$216 \$217 VDD \$235 \$7 \$7 \$219 \$229 SUB B04_OTA
X$205 \$215 VbiasN VDD \$214 \$228 \$213 VbiasP SUB B04_OTA_bias_ratio_025
X$206 \$221 VbiasN VDD \$220 \$230 \$218 VbiasP SUB B04_OTA_bias_ratio_04
X$207 \$224 VbiasN VDD \$223 \$227 \$222 VbiasP SUB B04_OTA_bias_ratio_04
X$208 \$219 VbiasN VDD \$217 \$229 \$216 VbiasP SUB B04_OTA_bias_ratio_025
X$209 SUB \$216 \$217 VDD \$235 \$239 \$239 \$219 \$229 SUB B04_OTA
X$210 SUB \$213 \$214 VDD Vin \$235 \$239 \$215 \$228 SUB B04_OTA
X$211 SUB \$222 \$223 VDD \$235 \$242 \$239 \$224 \$227 SUB B04_OTA
X$212 SUB \$218 \$220 VDD \$239 \$235 \$242 \$221 \$230 SUB B04_OTA
C$1 SUB \$239 1.28e-11 cap_mim_2f0fF A=6400P P=2560U
C$2 SUB \$7 1.28e-11 cap_mim_2f0fF A=6400P P=2560U
C$3 SUB \$6 1.28e-11 cap_mim_2f0fF A=6400P P=2560U
C$6 SUB \$242 1.28e-11 cap_mim_2f0fF A=6400P P=2560U
C$34 SUB SUB 2.88e-11 cap_mim_2f0fF A=14400P P=5760U
.ENDS B04_BPF4

.SUBCKT B04_OTA_bias_ratio_04 Vbias3 VbiasN VDD Vbias1 Vbias0 Vbias2 VbiasP GND
M$1 Vbias2 VbiasP VDD VDD pfet_03v3 L=4U W=2U AS=0.88P AD=0.88P PS=4.88U
+ PD=4.88U
M$2 Vbias3 VbiasN GND GND nfet_03v3 L=4U W=4U AS=1.76P AD=1.76P PS=8.88U
+ PD=8.88U
M$3 \$9 Vbias1 GND GND nfet_03v3 L=4U W=1U AS=0.44P AD=0.44P PS=2.88U PD=2.88U
M$4 Vbias1 Vbias2 \$9 GND nfet_03v3 L=4U W=1U AS=0.44P AD=0.44P PS=2.88U
+ PD=2.88U
M$5 Vbias3 VDD Vbias0 GND nfet_03v3 L=4U W=10U AS=4.4P AD=4.4P PS=20.88U
+ PD=20.88U
M$6 Vbias0 Vbias3 \$13 VDD pfet_03v3 L=4U W=5U AS=2.2P AD=2.2P PS=10.88U
+ PD=10.88U
M$7 \$13 Vbias0 VDD VDD pfet_03v3 L=4U W=5U AS=2.2P AD=2.2P PS=10.88U PD=10.88U
M$8 Vbias1 GND Vbias2 VDD pfet_03v3 L=4U W=5U AS=2.2P AD=2.2P PS=10.88U
+ PD=10.88U
.ENDS B04_OTA_bias_ratio_04

.SUBCKT B04_OTA_bias_ratio_025 Vbias3 VbiasN VDD Vbias1 Vbias0 Vbias2 VbiasP GND
M$1 Vbias2 VbiasP VDD VDD pfet_03v3 L=4U W=1.25U AS=0.55P AD=0.55P PS=3.38U
+ PD=3.38U
M$2 Vbias3 VbiasN GND GND nfet_03v3 L=4U W=2.5U AS=1.1P AD=1.1P PS=5.88U
+ PD=5.88U
M$3 Vbias1 Vbias2 \$10 GND nfet_03v3 L=4U W=1U AS=0.44P AD=0.44P PS=2.88U
+ PD=2.88U
M$4 \$10 Vbias1 GND GND nfet_03v3 L=4U W=1U AS=0.44P AD=0.44P PS=2.88U PD=2.88U
M$5 Vbias3 VDD Vbias0 GND nfet_03v3 L=4U W=10U AS=4.4P AD=4.4P PS=20.88U
+ PD=20.88U
M$6 Vbias0 Vbias3 \$14 VDD pfet_03v3 L=4U W=5U AS=2.2P AD=2.2P PS=10.88U
+ PD=10.88U
M$7 \$14 Vbias0 VDD VDD pfet_03v3 L=4U W=5U AS=2.2P AD=2.2P PS=10.88U PD=10.88U
M$8 Vbias1 GND Vbias2 VDD pfet_03v3 L=4U W=5U AS=2.2P AD=2.2P PS=10.88U
+ PD=10.88U
.ENDS B04_OTA_bias_ratio_025

.SUBCKT B04_OTA GND Vbias2 Vbias1 VDD Vin+ Vin\x2d Vout Vbias3 Vbias0 SUB
M$1 GND GND GND SUB nfet_03v3 L=4U W=7U AS=3.08P AD=3.08P PS=22.8U PD=22.8U
M$5 \$17 Vbias0 VDD VDD pfet_03v3 L=4U W=10U AS=3.5P AD=3.5P PS=16.4U PD=16.4U
M$7 \$5 Vin+ \$17 VDD pfet_03v3 L=1U W=18U AS=5.76P AD=5.76P PS=29.76U PD=29.76U
M$8 \$17 Vin\x2d \$6 VDD pfet_03v3 L=1U W=18U AS=5.76P AD=5.76P PS=29.76U
+ PD=29.76U
M$9 VDD VDD VDD VDD pfet_03v3 L=1U W=8U AS=3.52P AD=3.52P PS=19.52U PD=19.52U
M$27 \$3 Vin\x2d \$17 VDD pfet_03v3 L=1U W=2U AS=0.88P AD=0.88P PS=4.88U
+ PD=4.88U
M$28 \$17 Vin+ \$7 VDD pfet_03v3 L=1U W=2U AS=0.88P AD=0.88P PS=4.88U PD=4.88U
M$31 \$7 Vbias2 \$4 SUB nfet_03v3 L=1U W=2U AS=0.7P AD=0.7P PS=4.4U PD=4.4U
M$33 GND GND GND SUB nfet_03v3 L=1U W=2U AS=0.88P AD=0.88P PS=5.76U PD=5.76U
M$35 \$2 Vbias2 \$3 SUB nfet_03v3 L=1U W=2U AS=0.88P AD=0.88P PS=5.76U PD=5.76U
M$37 \$4 \$7 GND SUB nfet_03v3 L=4U W=1U AS=0.44P AD=0.44P PS=3.76U PD=3.76U
M$41 \$6 \$7 GND SUB nfet_03v3 L=4U W=1U AS=0.35P AD=0.35P PS=2.9U PD=2.9U
M$43 \$23 \$13 VDD VDD pfet_03v3 L=4U W=5U AS=1.75P AD=1.75P PS=8.9U PD=8.9U
M$45 VDD \$13 \$24 VDD pfet_03v3 L=4U W=5U AS=2.2P AD=2.2P PS=11.76U PD=11.76U
M$47 VDD VDD VDD VDD pfet_03v3 L=4U W=10U AS=4.4P AD=4.4P PS=23.52U PD=23.52U
M$49 \$23 Vbias3 Vout VDD pfet_03v3 L=4U W=5U AS=1.75P AD=1.75P PS=8.9U PD=8.9U
M$53 \$24 Vbias3 \$13 VDD pfet_03v3 L=4U W=5U AS=2.2P AD=2.2P PS=11.76U
+ PD=11.76U
M$55 \$2 \$3 GND SUB nfet_03v3 L=4U W=1U AS=0.35P AD=0.35P PS=2.9U PD=2.9U
M$57 Vout Vbias2 \$6 SUB nfet_03v3 L=4U W=1U AS=0.35P AD=0.35P PS=2.9U PD=2.9U
M$59 \$5 \$3 GND SUB nfet_03v3 L=4U W=1U AS=0.44P AD=0.44P PS=3.76U PD=3.76U
M$65 \$5 Vbias2 \$13 SUB nfet_03v3 L=4U W=1U AS=0.44P AD=0.44P PS=3.76U PD=3.76U
M$67 GND Vbias1 \$6 SUB nfet_03v3 L=4U W=10U AS=2.96P AD=2.96P PS=17.92U
+ PD=17.92U
M$77 \$5 Vbias1 GND SUB nfet_03v3 L=4U W=10U AS=2.96P AD=2.96P PS=17.92U
+ PD=17.92U
.ENDS B04_OTA
