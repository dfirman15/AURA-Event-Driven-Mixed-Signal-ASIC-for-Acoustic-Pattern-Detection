* Extracted by KLayout with GF180MCU LVS runset on : 02/09/2026 11:50

.SUBCKT B04_BPF4 Cap0 Cap1 Cap2 VbiasN VDD05 VbiasP VDD Vout Vin GND
X$1 \$755 \$745 \$63 VDD VDD05 \$51 \$756 \$761 GND B04_OTA
X$2 \$774 \$763 Vout VDD \$765 \$51 \$764 \$773 GND B04_OTA
X$3 \$753 \$744 \$51 VDD \$51 VDD05 \$754 \$760 GND B04_OTA
X$16 \$757 \$746 \$51 VDD \$63 VDD05 \$758 \$762 GND B04_OTA
X$17 \$751 \$743 \$51 VDD VDD05 \$821 \$752 \$759 GND B04_OTA
X$372 \$752 VbiasN VDD \$751 \$759 \$743 VbiasP GND B04_OTA_bias_ratio_025
X$373 \$756 VbiasN VDD \$755 \$761 \$745 VbiasP GND B04_OTA_bias_ratio_04
X$374 \$764 VbiasN VDD \$773 \$774 \$763 VbiasP GND B04_OTA_bias_ratio_5
X$375 \$758 VbiasN VDD \$757 \$762 \$746 VbiasP GND B04_OTA_bias_ratio_04
X$376 \$754 VbiasN VDD \$753 \$760 \$744 VbiasP GND B04_OTA_bias_ratio_025
X$377 \$753 \$744 \$821 VDD \$821 VDD05 \$754 \$760 GND B04_OTA
X$378 \$757 \$746 \$821 VDD \$852 VDD05 \$758 \$762 GND B04_OTA
X$379 \$751 \$743 \$821 VDD VDD05 Vin \$752 \$759 GND B04_OTA
X$380 \$755 \$745 \$852 VDD VDD05 \$821 \$756 \$761 GND B04_OTA
C$1 GND GND 3.84e-11 cap_mim_2f0fF A=19200P P=7680U
C$30 \$52 \$51 8e-12 cap_mim_2f0fF A=4000P P=1600U
C$34 \$64 \$63 2e-12 cap_mim_2f0fF A=1000P P=400U
C$59 \$95 \$63 4e-12 cap_mim_2f0fF A=2000P P=800U
C$106 GND \$63 1e-11 cap_mim_2f0fF A=5000P P=2000U
C$128 GND \$51 1e-11 cap_mim_2f0fF A=5000P P=2000U
C$226 \$437 \$63 8e-12 cap_mim_2f0fF A=4000P P=1600U
C$248 \$472 \$51 4e-12 cap_mim_2f0fF A=2000P P=800U
C$297 \$573 \$51 2e-12 cap_mim_2f0fF A=1000P P=400U
C$328 \$765 VDD05 4e-12 cap_mim_2f0fF A=2000P P=800U
C$335 \$765 Vout 2e-13 cap_mim_2f0fF A=100P P=40U
C$387 \$864 \$821 2e-12 cap_mim_2f0fF A=1000P P=400U
C$390 \$874 \$852 8e-12 cap_mim_2f0fF A=4000P P=1600U
C$413 \$865 \$821 4e-12 cap_mim_2f0fF A=2000P P=800U
C$461 GND \$821 1e-11 cap_mim_2f0fF A=5000P P=2000U
C$484 GND \$852 1e-11 cap_mim_2f0fF A=5000P P=2000U
C$589 \$866 \$821 8e-12 cap_mim_2f0fF A=4000P P=1600U
C$608 \$873 \$852 4e-12 cap_mim_2f0fF A=2000P P=800U
C$654 \$871 \$852 2e-12 cap_mim_2f0fF A=1000P P=400U
M$694 Vout Vout \$765 \$765 pfet_03v3 L=4U W=0.5U AS=0.22P AD=0.22P PS=1.88U
+ PD=1.88U
M$695 Vout \$765 \$765 Vout pfet_03v3 L=4U W=0.5U AS=0.22P AD=0.22P PS=1.88U
+ PD=1.88U
M$696 GND Cap2 \$52 GND nfet_03v3 L=1U W=0.5U AS=0.22P AD=0.22P PS=1.88U
+ PD=1.88U
M$697 GND Cap0 \$64 GND nfet_03v3 L=1U W=0.5U AS=0.22P AD=0.22P PS=1.88U
+ PD=1.88U
M$698 GND Cap1 \$95 GND nfet_03v3 L=1U W=0.5U AS=0.22P AD=0.22P PS=1.88U
+ PD=1.88U
M$699 GND Cap2 \$437 GND nfet_03v3 L=1U W=0.5U AS=0.22P AD=0.22P PS=1.88U
+ PD=1.88U
M$700 GND Cap1 \$472 GND nfet_03v3 L=1U W=0.5U AS=0.22P AD=0.22P PS=1.88U
+ PD=1.88U
M$701 GND Cap0 \$573 GND nfet_03v3 L=1U W=0.5U AS=0.22P AD=0.22P PS=1.88U
+ PD=1.88U
M$702 GND Cap0 \$864 GND nfet_03v3 L=1U W=0.5U AS=0.22P AD=0.22P PS=1.88U
+ PD=1.88U
M$703 GND Cap0 \$871 GND nfet_03v3 L=1U W=0.5U AS=0.22P AD=0.22P PS=1.88U
+ PD=1.88U
M$704 GND Cap1 \$865 GND nfet_03v3 L=1U W=0.5U AS=0.22P AD=0.22P PS=1.88U
+ PD=1.88U
M$705 GND Cap1 \$873 GND nfet_03v3 L=1U W=0.5U AS=0.22P AD=0.22P PS=1.88U
+ PD=1.88U
M$706 GND Cap2 \$866 GND nfet_03v3 L=1U W=0.5U AS=0.22P AD=0.22P PS=1.88U
+ PD=1.88U
M$707 GND Cap2 \$874 GND nfet_03v3 L=1U W=0.5U AS=0.22P AD=0.22P PS=1.88U
+ PD=1.88U
.ENDS B04_BPF4

.SUBCKT B04_OTA Vbias1 Vbias2 Vout VDD Vin\x2d Vin+ Vbias3 Vbias0 GND
M$1 \$16 Vbias0 VDD VDD pfet_03v3 L=4U W=5U AS=1.75P AD=1.75P PS=8.9U PD=8.9U
M$3 Vout Vbias3 \$19 VDD pfet_03v3 L=4U W=5U AS=2.2P AD=2.2P PS=11.76U PD=11.76U
M$5 VDD \$11 \$19 VDD pfet_03v3 L=4U W=5U AS=2.2P AD=2.2P PS=11.76U PD=11.76U
M$6 VDD \$11 \$21 VDD pfet_03v3 L=4U W=5U AS=2.2P AD=2.2P PS=11.76U PD=11.76U
M$9 \$21 Vbias3 \$11 VDD pfet_03v3 L=4U W=5U AS=2.2P AD=2.2P PS=11.76U PD=11.76U
M$11 VDD VDD VDD VDD pfet_03v3 L=4U W=10U AS=4.4P AD=4.4P PS=23.52U PD=23.52U
M$15 \$5 Vin\x2d \$16 VDD pfet_03v3 L=1U W=2U AS=0.61P AD=0.61P PS=4.94U
+ PD=4.94U
M$19 \$9 Vin+ \$16 VDD pfet_03v3 L=1U W=2U AS=0.61P AD=0.61P PS=4.94U PD=4.94U
M$23 \$3 Vin+ \$16 VDD pfet_03v3 L=1U W=2U AS=0.61P AD=0.61P PS=4.94U PD=4.94U
M$27 \$4 Vin\x2d \$16 VDD pfet_03v3 L=1U W=2U AS=0.61P AD=0.61P PS=4.94U
+ PD=4.94U
M$31 VDD VDD VDD VDD pfet_03v3 L=1U W=2U AS=0.88P AD=0.88P PS=7.52U PD=7.52U
M$35 \$2 Vbias2 \$5 GND nfet_03v3 L=1U W=2U AS=0.88P AD=0.88P PS=5.76U PD=5.76U
M$36 \$9 Vbias2 \$7 GND nfet_03v3 L=1U W=2U AS=0.88P AD=0.88P PS=5.76U PD=5.76U
M$37 GND GND GND GND nfet_03v3 L=1U W=4U AS=1.76P AD=1.76P PS=11.52U PD=11.52U
M$43 GND \$5 \$2 GND nfet_03v3 L=4U W=1U AS=0.44P AD=0.44P PS=3.76U PD=3.76U
M$44 \$3 Vbias1 GND GND nfet_03v3 L=4U W=1U AS=0.44P AD=0.44P PS=3.76U PD=3.76U
M$45 \$3 \$5 GND GND nfet_03v3 L=4U W=1U AS=0.44P AD=0.44P PS=3.76U PD=3.76U
M$46 GND \$9 \$4 GND nfet_03v3 L=4U W=1U AS=0.44P AD=0.44P PS=3.76U PD=3.76U
M$47 GND Vbias1 \$4 GND nfet_03v3 L=4U W=1U AS=0.44P AD=0.44P PS=3.76U PD=3.76U
M$48 \$7 \$9 GND GND nfet_03v3 L=4U W=1U AS=0.44P AD=0.44P PS=3.76U PD=3.76U
M$49 GND GND GND GND nfet_03v3 L=4U W=3U AS=1.32P AD=1.32P PS=11.28U PD=11.28U
M$52 \$3 Vbias2 \$11 GND nfet_03v3 L=4U W=1U AS=0.44P AD=0.44P PS=3.76U PD=3.76U
M$58 \$4 Vbias2 Vout GND nfet_03v3 L=4U W=1U AS=0.44P AD=0.44P PS=3.76U PD=3.76U
.ENDS B04_OTA

.SUBCKT B04_OTA_bias_ratio_5 Vbias3 VbiasN VDD Vbias0 Vbias1 Vbias2 VbiasP GND
M$1 Vbias2 VbiasP VDD VDD pfet_03v3 L=4U W=25U AS=11P AD=11P PS=50.88U PD=50.88U
M$2 Vbias3 VbiasN GND GND nfet_03v3 L=4U W=50U AS=22P AD=22P PS=100.88U
+ PD=100.88U
M$3 \$10 Vbias1 GND GND nfet_03v3 L=4U W=1U AS=0.44P AD=0.44P PS=2.88U PD=2.88U
M$4 Vbias1 Vbias2 \$10 GND nfet_03v3 L=4U W=1U AS=0.44P AD=0.44P PS=2.88U
+ PD=2.88U
M$5 Vbias3 VDD Vbias0 GND nfet_03v3 L=4U W=10U AS=4.4P AD=4.4P PS=20.88U
+ PD=20.88U
M$6 Vbias0 Vbias3 \$15 VDD pfet_03v3 L=4U W=5U AS=2.2P AD=2.2P PS=10.88U
+ PD=10.88U
M$7 \$15 Vbias0 VDD VDD pfet_03v3 L=4U W=5U AS=2.2P AD=2.2P PS=10.88U PD=10.88U
M$8 Vbias1 GND Vbias2 VDD pfet_03v3 L=4U W=5U AS=2.2P AD=2.2P PS=10.88U
+ PD=10.88U
.ENDS B04_OTA_bias_ratio_5

.SUBCKT B04_OTA_bias_ratio_04 Vbias3 VbiasN VDD Vbias1 Vbias0 Vbias2 VbiasP GND
M$1 Vbias2 VbiasP VDD VDD pfet_03v3 L=4U W=2U AS=0.88P AD=0.88P PS=4.88U
+ PD=4.88U
M$2 Vbias3 VbiasN GND GND nfet_03v3 L=4U W=4U AS=1.76P AD=1.76P PS=8.88U
+ PD=8.88U
M$3 Vbias1 Vbias2 \$9 GND nfet_03v3 L=4U W=1U AS=0.44P AD=0.44P PS=2.88U
+ PD=2.88U
M$4 \$9 Vbias1 GND GND nfet_03v3 L=4U W=1U AS=0.44P AD=0.44P PS=2.88U PD=2.88U
M$5 Vbias3 VDD Vbias0 GND nfet_03v3 L=4U W=10U AS=4.4P AD=4.4P PS=20.88U
+ PD=20.88U
M$6 Vbias0 Vbias3 \$13 VDD pfet_03v3 L=4U W=5U AS=2.2P AD=2.2P PS=10.88U
+ PD=10.88U
M$7 \$13 Vbias0 VDD VDD pfet_03v3 L=4U W=5U AS=2.2P AD=2.2P PS=10.88U PD=10.88U
M$8 Vbias1 GND Vbias2 VDD pfet_03v3 L=4U W=5U AS=2.2P AD=2.2P PS=10.88U
+ PD=10.88U
.ENDS B04_OTA_bias_ratio_04

.SUBCKT B04_OTA_bias_ratio_025 Vbias3 VbiasN VDD Vbias1 Vbias0 Vbias2 VbiasP GND
M$1 Vbias2 VbiasP VDD VDD pfet_03v3 L=4U W=1.25U AS=0.55P AD=0.55P PS=3.38U
+ PD=3.38U
M$2 Vbias3 VbiasN GND GND nfet_03v3 L=4U W=2.5U AS=1.1P AD=1.1P PS=5.88U
+ PD=5.88U
M$3 Vbias1 Vbias2 \$10 GND nfet_03v3 L=4U W=1U AS=0.44P AD=0.44P PS=2.88U
+ PD=2.88U
M$4 \$10 Vbias1 GND GND nfet_03v3 L=4U W=1U AS=0.44P AD=0.44P PS=2.88U PD=2.88U
M$5 Vbias3 VDD Vbias0 GND nfet_03v3 L=4U W=10U AS=4.4P AD=4.4P PS=20.88U
+ PD=20.88U
M$6 Vbias0 Vbias3 \$14 VDD pfet_03v3 L=4U W=5U AS=2.2P AD=2.2P PS=10.88U
+ PD=10.88U
M$7 \$14 Vbias0 VDD VDD pfet_03v3 L=4U W=5U AS=2.2P AD=2.2P PS=10.88U PD=10.88U
M$8 Vbias1 GND Vbias2 VDD pfet_03v3 L=4U W=5U AS=2.2P AD=2.2P PS=10.88U
+ PD=10.88U
.ENDS B04_OTA_bias_ratio_025
