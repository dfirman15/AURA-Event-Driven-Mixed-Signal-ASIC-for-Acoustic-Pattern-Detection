* SPICE3 file created from B04_BMR.ext - technology: gf180mcuD

.option scale=10n

.subckt B04_BMR VDD GND VbiasP VbiasN
X0 VDD B04_diff_amp_0/m1_n240_n310# B04_diff_amp_0/m1_n240_n310# VDD pfet_03v3 ad=28.6n pd=1.388m as=28.6n ps=1.388m w=650 l=400
X1 VDD VDD VDD VDD pfet_03v3 ad=0.2662u pd=0.0136 as=0 ps=0 w=650 l=400
X2 B04_diff_amp_0/m1_n240_n310# B04_diff_amp_0/m1_n240_n310# VDD VDD pfet_03v3 ad=57.2n pd=2.776m as=0 ps=0 w=650 l=400
X3 VbiasP VbiasN B04_diff_amp_0/m1_630_n2010# GND nfet_03v3 ad=2.42n pd=0.198m as=2.42n ps=0.198m w=55 l=400
X4 B04_diff_amp_0/m1_630_n2010# VbiasN VbiasP GND nfet_03v3 ad=19.36n pd=1.32m as=9.24n ps=0.684m w=55 l=400
X5 B04_diff_amp_0/m1_630_n2010# B04_diff_amp_0/V+ B04_diff_amp_0/m1_n240_n310# GND nfet_03v3 ad=0 pd=0 as=4.84n ps=0.396m w=55 l=400
X6 B04_diff_amp_0/m1_n240_n310# B04_diff_amp_0/V+ B04_diff_amp_0/m1_630_n2010# GND nfet_03v3 ad=0 pd=0 as=0 ps=0 w=55 l=400
X7 GND VbiasN B04_diff_amp_0/m1_630_n2010# GND nfet_03v3 ad=9.68n pd=0.528m as=9.68n ps=0.528m w=220 l=400
X8 GND GND GND GND nfet_03v3 ad=0.32736u pd=0.01585 as=0 ps=0 w=55 l=400
X9 GND GND GND GND nfet_03v3 ad=0 pd=0 as=0 ps=0 w=55 l=400
X10 VbiasP B04_diff_amp_0/m1_n240_n310# VDD VDD pfet_03v3 ad=57.2n pd=2.776m as=0 ps=0 w=650 l=400
X11 VDD B04_diff_amp_0/m1_n240_n310# VbiasP VDD pfet_03v3 ad=0 pd=0 as=0 ps=0 w=650 l=400
X12 VDD VDD VDD VDD pfet_03v3 ad=0 pd=0 as=0 ps=0 w=650 l=400
X13 VDD VDD VDD VDD pfet_03v3 ad=4.4n pd=0.288m as=4.4n ps=0.288m w=100 l=400
X14 GND GND GND GND nfet_03v3 ad=44n pd=2.088m as=44n ps=2.088m w=1000 l=400
X15 GND GND GND GND nfet_03v3 ad=0 pd=0 as=0 ps=0 w=1000 l=400
X16 B04_diff_amp_0/V+ VbiasP VDD VDD pfet_03v3 ad=8.8n pd=0.576m as=0 ps=0 w=100 l=400
X17 VDD VbiasP B04_diff_amp_0/V+ VDD pfet_03v3 ad=0 pd=0 as=0 ps=0 w=100 l=400
X18 m1_750_10240# m1_1230_1850# GND ppolyf_u_1k r_width=200 r_length=4100
X19 m1_1710_10240# m1_2190_1850# GND ppolyf_u_1k r_width=200 r_length=4100
X20 m1_1710_10240# m1_1230_1850# GND ppolyf_u_1k r_width=200 r_length=4100
X21 m1_2670_10240# m1_3150_1850# GND ppolyf_u_1k r_width=200 r_length=4100
X22 m1_5550_10240# m1_5070_1850# GND ppolyf_u_1k r_width=200 r_length=4100
X23 m1_2670_10240# m1_2190_1850# GND ppolyf_u_1k r_width=200 r_length=4100
X24 m1_4590_10240# m1_5070_1850# GND ppolyf_u_1k r_width=200 r_length=4100
X25 m1_8430_10240# GND GND ppolyf_u_1k r_width=200 r_length=4100
X26 m1_8430_10240# m1_7950_1850# GND ppolyf_u_1k r_width=200 r_length=4100
X27 m1_3630_10240# m1_4110_1850# GND ppolyf_u_1k r_width=200 r_length=4100
X28 m1_3630_10240# m1_3150_1850# GND ppolyf_u_1k r_width=200 r_length=4100
X29 m1_n210_10240# m1_270_1850# GND ppolyf_u_1k r_width=200 r_length=4100
X30 m1_4590_10240# m1_4110_1850# GND ppolyf_u_1k r_width=200 r_length=4100
X31 m1_n210_10240# m1_n13920_7340# GND ppolyf_u_1k r_width=200 r_length=4100
X32 m1_750_10240# m1_270_1850# GND ppolyf_u_1k r_width=200 r_length=4100
X33 m1_7470_10240# m1_7950_1850# GND ppolyf_u_1k r_width=200 r_length=4100
X34 m1_6510_10240# m1_6990_1850# GND ppolyf_u_1k r_width=200 r_length=4100
X35 m1_7470_10240# m1_6990_1850# GND ppolyf_u_1k r_width=200 r_length=4100
X36 m1_5550_10240# m1_6030_1850# GND ppolyf_u_1k r_width=200 r_length=4100
X37 m1_6510_10240# m1_6030_1850# GND ppolyf_u_1k r_width=200 r_length=4100
X38 VbiasP VbiasN cap_mim_2f0_m4m5_noshield c_width=1000 c_length=1000
X39 VbiasP VbiasN cap_mim_2f0_m4m5_noshield c_width=1000 c_length=1000
X40 VbiasP VbiasN cap_mim_2f0_m4m5_noshield c_width=1000 c_length=1000
X41 VbiasP VbiasN cap_mim_2f0_m4m5_noshield c_width=1000 c_length=1000
X42 VbiasP VbiasN cap_mim_2f0_m4m5_noshield c_width=1000 c_length=1000
X43 VbiasP VbiasN cap_mim_2f0_m4m5_noshield c_width=1000 c_length=1000
X44 VbiasP VbiasN cap_mim_2f0_m4m5_noshield c_width=1000 c_length=1000
X45 VbiasP VbiasN cap_mim_2f0_m4m5_noshield c_width=1000 c_length=1000
X46 VDD VDD VDD VDD pfet_03v3 ad=0 pd=0 as=0 ps=0 w=100 l=400
X47 VbiasP VbiasN cap_mim_2f0_m4m5_noshield c_width=1000 c_length=1000
X48 VbiasP VbiasN cap_mim_2f0_m4m5_noshield c_width=1000 c_length=1000
X49 VbiasP VbiasN cap_mim_2f0_m4m5_noshield c_width=1000 c_length=1000
X50 VbiasP VbiasN cap_mim_2f0_m4m5_noshield c_width=1000 c_length=1000
X51 VbiasP VbiasN cap_mim_2f0_m4m5_noshield c_width=1000 c_length=1000
X52 VbiasP VbiasN cap_mim_2f0_m4m5_noshield c_width=1000 c_length=1000
X53 VbiasP VbiasN cap_mim_2f0_m4m5_noshield c_width=1000 c_length=1000
X54 VbiasP VbiasN cap_mim_2f0_m4m5_noshield c_width=1000 c_length=1000
X55 VbiasP VbiasN cap_mim_2f0_m4m5_noshield c_width=1000 c_length=1000
X56 VbiasP VbiasN cap_mim_2f0_m4m5_noshield c_width=1000 c_length=1000
X57 VbiasP VbiasN cap_mim_2f0_m4m5_noshield c_width=1000 c_length=1000
X58 VbiasP VbiasN cap_mim_2f0_m4m5_noshield c_width=1000 c_length=1000
X59 VDD m1_n15420_9660# m1_n15420_9660# VDD pfet_03v3 ad=2.2n pd=0.188m as=2.2n ps=0.188m w=50 l=4000
X60 VbiasP m1_n16340_7940# VbiasN GND nfet_03v3 ad=4.4n pd=0.288m as=4.4n ps=0.288m w=100 l=100
X61 m1_n16340_7940# VbiasN GND GND nfet_03v3 ad=88n pd=4.088m as=88n ps=4.088m w=2000 l=100
X62 GND VbiasN VbiasN GND nfet_03v3 ad=0 pd=0 as=48.4n ps=2.376m w=1000 l=400
X63 m1_n7420_9600# m1_n16340_7940# m1_n16340_7940# VDD pfet_03v3 ad=4.4n pd=0.376m as=2.2n ps=0.188m w=50 l=4000
X64 m1_n7420_9600# m1_n7420_9600# m1_n15420_9660# VDD pfet_03v3 ad=0 pd=0 as=4.4n ps=0.376m w=50 l=4000
X65 VDD VbiasP VbiasN VDD pfet_03v3 ad=0 pd=0 as=8.8n ps=0.576m w=100 l=400
X66 VbiasN VbiasP VDD VDD pfet_03v3 ad=0 pd=0 as=0 ps=0 w=100 l=400
X67 m1_n13920_7340# VbiasN B04_diff_amp_0/V+ GND nfet_03v3 ad=44n pd=2.088m as=26n ps=1.052m w=1000 l=400
X68 B04_diff_amp_0/V+ VbiasN m1_n13920_7340# GND nfet_03v3 ad=26n pd=1.052m as=44n ps=2.088m w=1000 l=400
X69 m1_n13920_7340# VbiasN B04_diff_amp_0/V+ GND nfet_03v3 ad=0.176u pd=8.352m as=0.104u ps=4.208m w=1000 l=400
X70 B04_diff_amp_0/V+ VbiasN m1_n13920_7340# GND nfet_03v3 ad=0 pd=0 as=0 ps=0 w=1000 l=400
C0 VbiasP m1_4110_1850# 0.0056f
C1 m1_6030_1850# VbiasN 0.00694f
C2 m1_n15420_9660# m1_n7420_9600# 5.7502f
C3 m1_2670_10240# m1_3630_10240# 0.10315f
C4 m1_750_10240# m1_n210_10240# 0.08984f
C5 m1_5070_1850# VbiasP 0.01134f
C6 m1_n16340_7940# VDD 13.02397f
C7 m1_2190_1850# m1_3150_1850# 0.08982f
C8 m1_2190_1850# VbiasN 0.0085f
C9 VDD VbiasP 9.41831f
C10 m1_n7420_9600# VbiasN 0.00174f
C11 m1_7950_1850# VbiasN 0.0085f
C12 m1_5070_1850# m1_4110_1850# 0.08982f
C13 VbiasN B04_diff_amp_0/m1_630_n2010# 1.70437f
C14 m1_6990_1850# VbiasN 0.00869f
C15 VbiasP B04_diff_amp_0/m1_n240_n310# 1.27624f
C16 m1_6990_1850# m1_6030_1850# 0.08982f
C17 B04_diff_amp_0/V+ VbiasP 1.65796f
C18 m1_n13920_7340# m1_1230_1850# 0.00149f
C19 VbiasN m1_1230_1850# 0.00663f
C20 VDD m1_n210_10240# 0.00477f
C21 m1_4590_10240# m1_5550_10240# 0.08984f
C22 m1_n16340_7940# m1_n15420_9660# 0.02652f
C23 m1_6990_1850# m1_7950_1850# 0.08982f
C24 VDD B04_diff_amp_0/m1_n240_n310# 10.72447f
C25 m1_2190_1850# m1_1230_1850# 0.08982f
C26 m1_n16340_7940# m1_n13920_7340# 0.25014f
C27 m1_n16340_7940# VbiasN 0.99831f
C28 m1_270_1850# m1_n13920_7340# 0.08791f
C29 m1_270_1850# VbiasN 0.00944f
C30 m1_2670_10240# m1_1710_10240# 0.08984f
C31 VbiasP m1_3150_1850# 0.01042f
C32 B04_diff_amp_0/V+ VDD 0.99967f
C33 VbiasP m1_n13920_7340# 0.80784f
C34 VbiasP VbiasN 19.91101f
C35 m1_6030_1850# VbiasP 0.00663f
C36 B04_diff_amp_0/V+ B04_diff_amp_0/m1_n240_n310# 1.50052f
C37 m1_4110_1850# m1_3150_1850# 0.08982f
C38 m1_750_10240# m1_1710_10240# 0.08984f
C39 m1_n15420_9660# VDD 13.76358f
C40 VbiasN m1_4110_1850# 0.00558f
C41 m1_n16340_7940# m1_n7420_9600# 5.74744f
C42 m1_2190_1850# VbiasP 0.01134f
C43 m1_n7420_9600# VbiasP 0.00187f
C44 m1_7950_1850# VbiasP 0.01134f
C45 m1_5070_1850# VbiasN 0.0085f
C46 m1_4590_10240# m1_3630_10240# 0.08984f
C47 VbiasP B04_diff_amp_0/m1_630_n2010# 0.01685f
C48 m1_6030_1850# m1_5070_1850# 0.08982f
C49 m1_6990_1850# VbiasP 0.00899f
C50 VDD VbiasN 1.85691f
C51 m1_270_1850# m1_1230_1850# 0.08982f
C52 VbiasN B04_diff_amp_0/m1_n240_n310# 0.60577f
C53 VbiasP m1_1230_1850# 0.00381f
C54 m1_6510_10240# m1_7470_10240# 0.08984f
C55 B04_diff_amp_0/V+ m1_n13920_7340# 0.70786f
C56 VDD m1_n7420_9600# 7.47816f
C57 B04_diff_amp_0/V+ VbiasN 4.74368f
C58 m1_6510_10240# m1_5550_10240# 0.08927f
C59 B04_diff_amp_0/m1_n240_n310# B04_diff_amp_0/m1_630_n2010# 0
C60 m1_n16340_7940# VbiasP 0.24312f
C61 m1_270_1850# VbiasP 0.01177f
C62 m1_8430_10240# m1_7470_10240# 0.08984f
C63 B04_diff_amp_0/V+ B04_diff_amp_0/m1_630_n2010# 0.31787f
C64 VbiasN m1_3150_1850# 0.0089f
C65 VbiasN m1_n13920_7340# 6.13966f
R0 VbiasN B04_diff_amp_0/Vbias.n0 4.93583
R1 VbiasN B04_diff_amp_0/V-.n2 3.84033
R2 B04_diff_amp_0/V-.n2 B04_diff_amp_0/V-.n0 2.99957
R3 B04_diff_amp_0/V-.n2 B04_diff_amp_0/V-.n1 2.01338
R4 B04_diff_amp_0/V+.n2 B04_diff_amp_0/V+.n0 4.53505
R5 B04_diff_amp_0/V+ B04_diff_amp_0/V+.n2 2.40901
R6 B04_diff_amp_0/V+.n2 B04_diff_amp_0/V+.n1 2.04911
R7 B04_diff_amp_0/VDD.n5 B04_diff_amp_0/VDD.n3 11.7482
R8 B04_diff_amp_0/VDD.n1 B04_diff_amp_0/VDD.n0 7.44275
R9 B04_diff_amp_0/VDD.n7 B04_diff_amp_0/VDD.n6 7.44275
R10 VDD B04_diff_amp_0/VDD.n1 1.38214
R11 VDD B04_diff_amp_0/VDD.n7 1.29577
R12 B04_diff_amp_0/VDD.n3 B04_diff_amp_0/VDD.n2 0.694595
R13 B04_diff_amp_0/VDD.n5 B04_diff_amp_0/VDD.n4 0.643827
R14 B04_diff_amp_0/VDD.n3 B04_diff_amp_0/VDD.n1 0.0831125
R15 B04_diff_amp_0/VDD.n7 B04_diff_amp_0/VDD.n5 0.0753336
R16 B04_diff_amp_0/GND.n2 B04_diff_amp_0/GND.n1 4.64868
R17 B04_diff_amp_0/GND.n5 B04_diff_amp_0/GND.n4 4.64107
R18 B04_diff_amp_0/GND.n2 B04_diff_amp_0/GND.n0 2.12816
R19 B04_diff_amp_0/GND.n5 B04_diff_amp_0/GND.n3 2.12188
R20 B04_diff_amp_0/GND.n6 B04_diff_amp_0/GND.n2 2.01437
R21 B04_diff_amp_0/GND.n6 B04_diff_amp_0/GND.n5 1.90693
R22 GND B04_diff_amp_0/GND.n6 0.454056
R23 VbiasP.n45 VbiasP.n44 7.89265
R24 VbiasP VbiasP.n37 7.23837
R25 VbiasP.n45 VbiasP 4.0855
R26 VbiasP.n40 VbiasP.n38 2.11858
R27 VbiasP.n42 VbiasP.n41 2.08115
R28 VbiasP.n44 VbiasP.n43 1.21341
R29 VbiasP.n40 VbiasP.n39 1.21325
R30 VbiasP.n42 VbiasP.n40 0.764609
R31 VbiasP.n15 VbiasP.n13 0.160449
R32 VbiasP.n2 VbiasP.n0 0.160449
R33 VbiasP.n30 VbiasP.n28 0.160449
R34 VbiasP.n25 VbiasP.n23 0.160449
R35 VbiasP.n37 VbiasP.n22 0.126426
R36 VbiasP.n17 VbiasP.n15 0.123259
R37 VbiasP.n19 VbiasP.n17 0.123259
R38 VbiasP.n21 VbiasP.n19 0.123259
R39 VbiasP.n4 VbiasP.n2 0.123259
R40 VbiasP.n6 VbiasP.n4 0.123259
R41 VbiasP.n8 VbiasP.n6 0.123259
R42 VbiasP.n10 VbiasP.n8 0.123259
R43 VbiasP.n12 VbiasP.n10 0.123259
R44 VbiasP.n32 VbiasP.n30 0.123259
R45 VbiasP.n34 VbiasP.n32 0.123259
R46 VbiasP.n36 VbiasP.n34 0.123259
R47 VbiasP.n27 VbiasP.n25 0.123259
R48 VbiasP.n22 VbiasP.n12 0.111159
R49 VbiasP.n37 VbiasP.n27 0.110959
R50 VbiasP VbiasP.n45 0.0655
R51 VbiasP.n44 VbiasP.n42 0.0479559
R52 VbiasP.n15 VbiasP.n14 0.0376901
R53 VbiasP.n17 VbiasP.n16 0.0376901
R54 VbiasP.n19 VbiasP.n18 0.0376901
R55 VbiasP.n2 VbiasP.n1 0.0376901
R56 VbiasP.n4 VbiasP.n3 0.0376901
R57 VbiasP.n6 VbiasP.n5 0.0376901
R58 VbiasP.n8 VbiasP.n7 0.0376901
R59 VbiasP.n10 VbiasP.n9 0.0376901
R60 VbiasP.n12 VbiasP.n11 0.0376901
R61 VbiasP.n21 VbiasP.n20 0.0376901
R62 VbiasP.n30 VbiasP.n29 0.0376901
R63 VbiasP.n32 VbiasP.n31 0.0376901
R64 VbiasP.n34 VbiasP.n33 0.0376901
R65 VbiasP.n25 VbiasP.n24 0.0376901
R66 VbiasP.n27 VbiasP.n26 0.0376901
R67 VbiasP.n36 VbiasP.n35 0.0376901
R68 VbiasP.n37 VbiasP.n36 0.0128
R69 VbiasP.n22 VbiasP.n21 0.0126
R70 VbiasN.n17 VbiasN.n15 86.8429
R71 VbiasN.n9 VbiasN.n7 11.2635
R72 VbiasN.n17 VbiasN.n16 10.6365
R73 VbiasN.n14 VbiasN.n13 10.6365
R74 VbiasN.n11 VbiasN.n10 10.6365
R75 VbiasN.n9 VbiasN.n8 10.6365
R76 VbiasN.n5 VbiasN.n4 4.42856
R77 VbiasN VbiasN.n18 4.35932
R78 VbiasN.n2 VbiasN.n0 2.99957
R79 VbiasN.n3 VbiasN.n2 2.38748
R80 VbiasN.n2 VbiasN.n1 2.01338
R81 VbiasN.n3 VbiasN 1.45336
R82 VbiasN.n12 VbiasN.n6 0.788582
R83 VbiasN.n11 VbiasN.n9 0.746965
R84 VbiasN.n5 VbiasN.n3 0.620364
R85 VbiasN.n14 VbiasN.n12 0.491502
R86 VbiasN VbiasN.n5 0.432693
R87 VbiasN.n18 VbiasN.n14 0.276391
R88 VbiasN.n12 VbiasN.n11 0.201336
R89 VbiasN.n18 VbiasN.n17 0.15852
R90 VDD.n21 VDD.n20 478.527
R91 VDD.n20 VDD.n19 13.4803
R92 VDD.n12 VDD.n5 11.7361
R93 VDD.n18 VDD.n17 7.44275
R94 VDD.n16 VDD.n15 7.44275
R95 VDD.n10 VDD.n9 4.54039
R96 VDD.n20 VDD 4.49632
R97 VDD.n22 VDD.n0 4.42785
R98 VDD.n24 VDD.n0 4.42417
R99 VDD.n11 VDD.n10 4.4205
R100 VDD.n22 VDD.n21 3.10258
R101 VDD.n23 VDD.n2 1.21376
R102 VDD.n9 VDD.n8 1.21325
R103 VDD.n7 VDD.n6 0.68469
R104 VDD.n5 VDD.n4 0.643827
R105 VDD.n13 VDD.n11 0.483986
R106 VDD VDD.n16 0.438864
R107 VDD.n18 VDD 0.412408
R108 VDD.n13 VDD.n12 0.213732
R109 VDD.n9 VDD.n3 0.100556
R110 VDD.n12 VDD.n7 0.0822845
R111 VDD.n14 VDD.n7 0.0657684
R112 VDD.n14 VDD.n13 0.0558279
R113 VDD.n19 VDD.n5 0.046991
R114 VDD.n24 VDD.n23 0.0416959
R115 VDD.n23 VDD.n22 0.0409536
R116 VDD.n21 VDD.n3 0.0256866
R117 VDD VDD.n1 0.023
R118 VDD.n24 VDD.n1 0.0205
R119 VDD.n19 VDD.n18 0.0145164
R120 VDD VDD.n24 0.0144175
R121 VDD.n1 VDD 0.0105
R122 VDD.n16 VDD.n14 0.00554098
R123 VDD.n11 VDD.n3 0.00117164
R124 GND.n26 GND.n25 275519
R125 GND.n25 GND.n6 86277
R126 GND.n14 GND.n7 2588.85
R127 GND.n28 GND.n27 2439.08
R128 GND.n24 GND.n8 678.097
R129 GND.n29 GND.n5 368.2
R130 GND.n16 GND.n15 272.014
R131 GND.n28 GND.n6 219.297
R132 GND.n27 GND.n26 155.404
R133 GND.n25 GND.n7 37.8375
R134 GND.n13 GND.n8 35.5773
R135 GND.n14 GND.n6 33.8547
R136 GND.n8 GND.n0 32.4475
R137 GND.n25 GND.n24 19.2807
R138 GND.n30 GND.n4 15.5919
R139 GND.n34 GND.n32 10.6383
R140 GND.n38 GND.n37 10.6365
R141 GND.n13 GND.n12 9.88336
R142 GND.n21 GND.n20 9.54208
R143 GND.n22 GND.n21 9.27868
R144 GND.n11 GND.n10 4.64107
R145 GND.n35 GND.n34 4.60009
R146 GND.n39 GND.n2 2.31454
R147 GND.n11 GND.n9 2.12188
R148 GND.n20 GND.n19 2.01338
R149 GND.n4 GND.n2 2.01264
R150 GND.n36 GND.n3 1.94214
R151 GND GND.n0 1.16012
R152 GND GND.n40 1.02685
R153 GND.n31 GND.n3 0.945604
R154 GND.n40 GND.n1 0.939071
R155 GND.n26 GND.n2 0.727368
R156 GND.n34 GND.n33 0.720657
R157 GND.n31 GND.n30 0.624071
R158 GND.n17 GND.n16 0.3255
R159 GND.n16 GND.n7 0.3255
R160 GND.n15 GND.n1 0.3255
R161 GND.n15 GND.n14 0.3255
R162 GND.n12 GND.n1 0.309071
R163 GND.n20 GND.n18 0.214916
R164 GND.n17 GND.n0 0.208007
R165 GND.n12 GND.n11 0.204944
R166 GND.n40 GND 0.175308
R167 GND.n30 GND.n29 0.158076
R168 GND.n29 GND.n28 0.158076
R169 GND.n5 GND.n4 0.158076
R170 GND.n27 GND.n5 0.158076
R171 GND.n23 GND.n13 0.0999102
R172 GND GND.n39 0.0835769
R173 GND.n18 GND.n17 0.0721622
R174 GND.n24 GND.n23 0.0716475
R175 GND.n39 GND.n38 0.0338333
R176 GND.n38 GND.n36 0.03325
R177 GND.n36 GND.n35 0.0256667
R178 GND.n22 GND.n18 0.0111166
R179 GND.n35 GND.n31 0.0100833
R180 GND.n23 GND.n22 0.00218901
C66 GND.n0 XM9/VSUBS 0 **FLOATING
C67 GND.n1 XM9/VSUBS 0 **FLOATING
C68 GND.n2 XM9/VSUBS 0 **FLOATING
C69 GND.n3 XM9/VSUBS 0 **FLOATING
C70 GND.n4 XM9/VSUBS 0 **FLOATING
C71 GND.n5 XM9/VSUBS 0 **FLOATING
C72 GND.n6 XM9/VSUBS 0.00335f **FLOATING
C73 GND.n7 XM9/VSUBS 0.01748f **FLOATING
C74 GND.n8 XM9/VSUBS 0.03982f **FLOATING
C75 GND.n9 XM9/VSUBS 0 **FLOATING
C76 GND.n10 XM9/VSUBS 0 **FLOATING
C77 GND.n11 XM9/VSUBS 0 **FLOATING
C78 GND.n12 XM9/VSUBS 0 **FLOATING
C79 GND.n13 XM9/VSUBS 0 **FLOATING
C80 GND.n14 XM9/VSUBS 0.01745f **FLOATING
C81 GND.n15 XM9/VSUBS 0 **FLOATING
C82 GND.n16 XM9/VSUBS 0 **FLOATING
C83 GND.n17 XM9/VSUBS 0 **FLOATING
C84 GND.n18 XM9/VSUBS 0 **FLOATING
C85 GND.n19 XM9/VSUBS 0 **FLOATING
C86 GND.n20 XM9/VSUBS 0 **FLOATING
C87 GND.n21 XM9/VSUBS 0 **FLOATING
C88 GND.n22 XM9/VSUBS 0 **FLOATING
C89 GND.n23 XM9/VSUBS 0 **FLOATING
C90 GND.n24 XM9/VSUBS 0.0388f **FLOATING
C91 GND.n25 XM9/VSUBS 0.00231f **FLOATING
C92 GND.n26 XM9/VSUBS 0.04606f **FLOATING
C93 GND.n27 XM9/VSUBS 0.02754f **FLOATING
C94 GND.n28 XM9/VSUBS 0.02818f **FLOATING
C95 GND.n29 XM9/VSUBS 0 **FLOATING
C96 GND.n30 XM9/VSUBS 0 **FLOATING
C97 GND.n31 XM9/VSUBS 0 **FLOATING
C98 GND.n32 XM9/VSUBS 0 **FLOATING
C99 GND.n33 XM9/VSUBS 0 **FLOATING
C100 GND.n34 XM9/VSUBS 0.00121f **FLOATING
C101 GND.n35 XM9/VSUBS 0 **FLOATING
C102 GND.n36 XM9/VSUBS 0 **FLOATING
C103 GND.n37 XM9/VSUBS 0 **FLOATING
C104 GND.n38 XM9/VSUBS 0 **FLOATING
C105 GND.n39 XM9/VSUBS 0 **FLOATING
C106 GND.n40 XM9/VSUBS 0 **FLOATING
C107 VDD.n0 XM9/VSUBS 0.00469f **FLOATING
C108 VDD.n1 XM9/VSUBS 0.00727f **FLOATING
C109 VDD.n2 XM9/VSUBS 0.03753f **FLOATING
C110 VDD.n3 XM9/VSUBS 0.0153f **FLOATING
C111 VDD.n4 XM9/VSUBS 0.04582f **FLOATING
C112 VDD.n5 XM9/VSUBS 1.40084f **FLOATING
C113 VDD.n6 XM9/VSUBS 0.0464f **FLOATING
C114 VDD.n7 XM9/VSUBS 0.006f **FLOATING
C115 VDD.n8 XM9/VSUBS 0.03752f **FLOATING
C116 VDD.n9 XM9/VSUBS 0.06412f **FLOATING
C117 VDD.n10 XM9/VSUBS 0.00509f **FLOATING
C118 VDD.n11 XM9/VSUBS 0.00963f **FLOATING
C119 VDD.n12 XM9/VSUBS 1.37857f **FLOATING
C120 VDD.n13 XM9/VSUBS 0.04726f **FLOATING
C121 VDD.n14 XM9/VSUBS 0.07846f **FLOATING
C122 VDD.n15 XM9/VSUBS 0.15172f **FLOATING
C123 VDD.n16 XM9/VSUBS 0.20882f **FLOATING
C124 VDD.n17 XM9/VSUBS 0.15172f **FLOATING
C125 VDD.n18 XM9/VSUBS 0.20552f **FLOATING
C126 VDD.n19 XM9/VSUBS 0.18665f **FLOATING
C127 VDD.n20 XM9/VSUBS 2.37365f **FLOATING
C128 VDD.n21 XM9/VSUBS 2.27902f **FLOATING
C129 VDD.n22 XM9/VSUBS 0.1802f **FLOATING
C130 VDD.n23 XM9/VSUBS 0.10624f **FLOATING
C131 VDD.n24 XM9/VSUBS 0.06034f **FLOATING
C132 VbiasN.n0 XM9/VSUBS 0.01489f **FLOATING
C133 VbiasN.n1 XM9/VSUBS 0.0102f **FLOATING
C134 VbiasN.n2 XM9/VSUBS 0.02214f **FLOATING
C135 VbiasN.n3 XM9/VSUBS 0.11243f **FLOATING
C136 VbiasN.n4 XM9/VSUBS 0.03666f **FLOATING
C137 VbiasN.n5 XM9/VSUBS 0.02476f **FLOATING
C138 VbiasN.n6 XM9/VSUBS 0.04362f **FLOATING
C139 VbiasN.n7 XM9/VSUBS 0.14331f **FLOATING
C140 VbiasN.n8 XM9/VSUBS 0.14001f **FLOATING
C141 VbiasN.n9 XM9/VSUBS 0.11677f **FLOATING
C142 VbiasN.n10 XM9/VSUBS 0.14001f **FLOATING
C143 VbiasN.n11 XM9/VSUBS 0.05661f **FLOATING
C144 VbiasN.n12 XM9/VSUBS 0.06631f **FLOATING
C145 VbiasN.n13 XM9/VSUBS 0.14001f **FLOATING
C146 VbiasN.n14 XM9/VSUBS 0.05553f **FLOATING
C147 VbiasN.n15 XM9/VSUBS 0.07226f **FLOATING
C148 VbiasN.n16 XM9/VSUBS 0.14001f **FLOATING
C149 VbiasN.n17 XM9/VSUBS 0.12145f **FLOATING
C150 VbiasN.n18 XM9/VSUBS 0.04824f **FLOATING
C151 VbiasP.n0 XM9/VSUBS 0.08109f **FLOATING
C152 VbiasP.n1 XM9/VSUBS 0.04545f **FLOATING
C153 VbiasP.n2 XM9/VSUBS 0.05823f **FLOATING
C154 VbiasP.n3 XM9/VSUBS 0.04545f **FLOATING
C155 VbiasP.n4 XM9/VSUBS 0.04743f **FLOATING
C156 VbiasP.n5 XM9/VSUBS 0.04545f **FLOATING
C157 VbiasP.n6 XM9/VSUBS 0.04743f **FLOATING
C158 VbiasP.n7 XM9/VSUBS 0.04545f **FLOATING
C159 VbiasP.n8 XM9/VSUBS 0.04743f **FLOATING
C160 VbiasP.n9 XM9/VSUBS 0.04545f **FLOATING
C161 VbiasP.n10 XM9/VSUBS 0.04743f **FLOATING
C162 VbiasP.n11 XM9/VSUBS 0.04545f **FLOATING
C163 VbiasP.n12 XM9/VSUBS 0.04559f **FLOATING
C164 VbiasP.n13 XM9/VSUBS 0.08109f **FLOATING
C165 VbiasP.n14 XM9/VSUBS 0.04545f **FLOATING
C166 VbiasP.n15 XM9/VSUBS 0.05823f **FLOATING
C167 VbiasP.n16 XM9/VSUBS 0.04545f **FLOATING
C168 VbiasP.n17 XM9/VSUBS 0.04743f **FLOATING
C169 VbiasP.n18 XM9/VSUBS 0.04545f **FLOATING
C170 VbiasP.n19 XM9/VSUBS 0.04743f **FLOATING
C171 VbiasP.n20 XM9/VSUBS 0.04545f **FLOATING
C172 VbiasP.n21 XM9/VSUBS 0.03059f **FLOATING
C173 VbiasP.n22 XM9/VSUBS 0.01998f **FLOATING
C174 VbiasP.n23 XM9/VSUBS 0.08102f **FLOATING
C175 VbiasP.n24 XM9/VSUBS 0.04545f **FLOATING
C176 VbiasP.n25 XM9/VSUBS 0.0582f **FLOATING
C177 VbiasP.n26 XM9/VSUBS 0.04545f **FLOATING
C178 VbiasP.n27 XM9/VSUBS 0.04557f **FLOATING
C179 VbiasP.n28 XM9/VSUBS 0.08109f **FLOATING
C180 VbiasP.n29 XM9/VSUBS 0.04545f **FLOATING
C181 VbiasP.n30 XM9/VSUBS 0.05823f **FLOATING
C182 VbiasP.n31 XM9/VSUBS 0.04545f **FLOATING
C183 VbiasP.n32 XM9/VSUBS 0.04743f **FLOATING
C184 VbiasP.n33 XM9/VSUBS 0.04545f **FLOATING
C185 VbiasP.n34 XM9/VSUBS 0.04743f **FLOATING
C186 VbiasP.n35 XM9/VSUBS 0.04545f **FLOATING
C187 VbiasP.n36 XM9/VSUBS 0.0307f **FLOATING
C188 VbiasP.n37 XM9/VSUBS 0.02704f **FLOATING
C189 VbiasP.n38 XM9/VSUBS 0.00339f **FLOATING
C190 VbiasP.n39 XM9/VSUBS 0.00227f **FLOATING
C191 VbiasP.n40 XM9/VSUBS 0.00493f **FLOATING
C192 VbiasP.n41 XM9/VSUBS 0.00336f **FLOATING
C193 VbiasP.n42 XM9/VSUBS 0.00322f **FLOATING
C194 VbiasP.n43 XM9/VSUBS 0.00229f **FLOATING
C195 VbiasP.n44 XM9/VSUBS 0.00356f **FLOATING
C196 VbiasP.n45 XM9/VSUBS 0.01538f **FLOATING
C197 B04_diff_amp_0/V+ XM9/VSUBS 9.24153f
C198 m1_n7420_9600# XM9/VSUBS 3.75234f **FLOATING
C199 m1_n16340_7940# XM9/VSUBS 12.48206f **FLOATING
C200 m1_n15420_9660# XM9/VSUBS 3.81038f **FLOATING
C201 VbiasP XM9/VSUBS 45.49583f
C202 VbiasN XM9/VSUBS 52.42167f
C203 m1_8430_10240# XM9/VSUBS 1.14551f **FLOATING
C204 m1_7950_1850# XM9/VSUBS 1.19528f **FLOATING
C205 m1_7470_10240# XM9/VSUBS 1.08704f **FLOATING
C206 m1_6990_1850# XM9/VSUBS 1.10457f **FLOATING
C207 m1_6510_10240# XM9/VSUBS 1.08683f **FLOATING
C208 m1_6030_1850# XM9/VSUBS 1.10457f **FLOATING
C209 m1_5550_10240# XM9/VSUBS 1.08695f **FLOATING
C210 m1_5070_1850# XM9/VSUBS 1.10457f **FLOATING
C211 m1_4590_10240# XM9/VSUBS 1.08683f **FLOATING
C212 m1_4110_1850# XM9/VSUBS 1.10457f **FLOATING
C213 m1_3630_10240# XM9/VSUBS 1.07008f **FLOATING
C214 m1_3150_1850# XM9/VSUBS 1.10457f **FLOATING
C215 m1_2670_10240# XM9/VSUBS 1.08683f **FLOATING
C216 m1_2190_1850# XM9/VSUBS 1.10457f **FLOATING
C217 m1_1710_10240# XM9/VSUBS 1.01582f **FLOATING
C218 m1_1230_1850# XM9/VSUBS 1.10457f **FLOATING
C219 m1_750_10240# XM9/VSUBS 0.98122f **FLOATING
C220 m1_270_1850# XM9/VSUBS 1.1116f **FLOATING
C221 m1_n13920_7340# XM9/VSUBS 11.98758f **FLOATING
C222 m1_n210_10240# XM9/VSUBS 1.0155f **FLOATING
C223 B04_diff_amp_0/GND.n0 XM9/VSUBS 0 **FLOATING
C224 B04_diff_amp_0/GND.n1 XM9/VSUBS 0 **FLOATING
C225 B04_diff_amp_0/GND.n2 XM9/VSUBS 0.00294f **FLOATING
C226 B04_diff_amp_0/GND.n3 XM9/VSUBS 0 **FLOATING
C227 B04_diff_amp_0/GND.n4 XM9/VSUBS 0 **FLOATING
C228 B04_diff_amp_0/GND.n5 XM9/VSUBS 0.00289f **FLOATING
C229 B04_diff_amp_0/GND.n6 XM9/VSUBS 0 **FLOATING
C230 B04_diff_amp_0/VDD.n0 XM9/VSUBS 0.2923f **FLOATING
C231 B04_diff_amp_0/VDD.n1 XM9/VSUBS 0.33283f **FLOATING
C232 B04_diff_amp_0/VDD.n2 XM9/VSUBS 0.09037f **FLOATING
C233 B04_diff_amp_0/VDD.n3 XM9/VSUBS 2.71567f **FLOATING
C234 B04_diff_amp_0/VDD.n4 XM9/VSUBS 0.08828f **FLOATING
C235 B04_diff_amp_0/VDD.n5 XM9/VSUBS 2.77105f **FLOATING
C236 B04_diff_amp_0/VDD.n6 XM9/VSUBS 0.2923f **FLOATING
C237 B04_diff_amp_0/VDD.n7 XM9/VSUBS 0.32852f **FLOATING
C238 B04_diff_amp_0/V+.n0 XM9/VSUBS 0.26119f **FLOATING
C239 B04_diff_amp_0/V+.n1 XM9/VSUBS 0.09101f **FLOATING
C240 B04_diff_amp_0/V+.n2 XM9/VSUBS 0.55996f **FLOATING
C241 B04_diff_amp_0/V-.n0 XM9/VSUBS 0.21506f **FLOATING
C242 B04_diff_amp_0/V-.n1 XM9/VSUBS 0.14731f **FLOATING
C243 B04_diff_amp_0/V-.n2 XM9/VSUBS 0.47695f **FLOATING
C244 B04_diff_amp_0/Vbias.n0 XM9/VSUBS 0.05745f **FLOATING
C245 VDD XM9/VSUBS 84.5244f
C246 B04_diff_amp_0/m1_630_n2010# XM9/VSUBS 1.11423f **FLOATING
C247 B04_diff_amp_0/m1_n240_n310# XM9/VSUBS 1.46501f **FLOATING
.ends
