* PEX produced on Thu Aug 13 07:40:30 PM CEST 2026 using /foss/tools/sak/iic-pex.sh with m=3 and s=1
* NGSPICE file created from B04_comparator.ext - technology: gf180mcuD

.subckt B04_comparator VDD Q_BAR INN INP IB GND
X0 a_3976_38.t0 INP.t0 a_4106_n890.t1 GND.t8 nfet_03v3 ad=0.86765p pd=4.88u as=0.86765p ps=4.88u w=2u l=0.28u
X1 a_2552_398.t3 a_3976_38.t5 VDD.t11 VDD.t10 pfet_03v3 ad=1.5179p pd=7.88u as=1.5179p ps=7.88u w=3.5u l=0.28u
X2 VDD.t7 a_2552_398.t4 a_3976_38.t3 VDD.t6 pfet_03v3 ad=1.5179p pd=7.88u as=1.5179p ps=7.88u w=3.5u l=0.28u
X3 a_2616_490.t1 a_2616_490.t0 GND.t5 GND.t4 nfet_03v3 ad=0.44p pd=2.88u as=0.44p ps=2.88u w=1u l=0.56u
X4 a_4106_n890.t0 IB.t2 GND.t3 GND.t2 nfet_03v3 ad=0.44p pd=2.88u as=0.44p ps=2.88u w=1u l=0.56u
X5 IB.t1 IB.t0 GND.t1 GND.t0 nfet_03v3 ad=0.44p pd=2.88u as=0.44p ps=2.88u w=1u l=0.56u
X6 Q_BAR.t0 a_2616_490.t3 GND.t7 GND.t6 nfet_03v3 ad=0.44p pd=2.88u as=0.44p ps=2.88u w=1u l=0.56u
X7 a_4106_n890.t2 INN.t0 a_2552_398.t2 GND.t9 nfet_03v3 ad=0.86765p pd=4.88u as=0.86765p ps=4.88u w=2u l=0.28u
X8 a_2616_490.t2 a_2552_398.t5 VDD.t9 VDD.t8 pfet_03v3 ad=0.6509p pd=3.88u as=0.6509p ps=3.88u w=1.5u l=0.28u
X9 VDD.t1 a_2552_398.t0 a_2552_398.t1 VDD.t0 pfet_03v3 ad=0.6509p pd=3.88u as=0.6509p ps=3.88u w=1.5u l=0.28u
X10 a_3976_38.t2 a_3976_38.t1 VDD.t5 VDD.t4 pfet_03v3 ad=0.6509p pd=3.88u as=0.6509p ps=3.88u w=1.5u l=0.28u
X11 VDD.t3 a_3976_38.t4 Q_BAR.t1 VDD.t2 pfet_03v3 ad=0.6509p pd=3.88u as=0.6509p ps=3.88u w=1.5u l=0.28u
R0 IB IB.n1 11.0521
R1 IB.n0 IB.t2 9.76983
R2 IB.n1 IB.t0 9.20614
R3 IB.n0 IB.t1 5.03499
R4 IB.n1 IB.n0 0.114829
R5 INP INP.t0 51.723
R6 INN INN.t0 51.153
R7 Q_BAR.n0 Q_BAR.t1 12.5811
R8 Q_BAR.n0 Q_BAR.t0 8.66712
R9 Q_BAR Q_BAR.n0 0.439893
R10 VDD.t8 VDD.t0 605.557
R11 VDD.t2 VDD.t4 605.557
R12 VDD.t6 VDD.t10 389.286
R13 VDD.t0 VDD.n13 304.038
R14 VDD.n14 VDD.t8 304.038
R15 VDD.n4 VDD.t2 304.038
R16 VDD.t4 VDD.n3 304.038
R17 VDD.n2 VDD.t6 195.344
R18 VDD.t10 VDD.n1 195.344
R19 VDD.n2 VDD.n1 78.7522
R20 VDD.n4 VDD.n3 61.2523
R21 VDD.n14 VDD.n13 61.2523
R22 VDD VDD.t9 3.5599
R23 VDD.n5 VDD.t3 3.50276
R24 VDD.n6 VDD.t5 3.49494
R25 VDD.n0 VDD.t1 3.41402
R26 VDD.n10 VDD.t11 2.34754
R27 VDD.n9 VDD.t7 2.32759
R28 VDD VDD.n14 1.91385
R29 VDD.n13 VDD.n12 1.87604
R30 VDD.n5 VDD.n4 1.87354
R31 VDD.n7 VDD.n3 1.84123
R32 VDD.n8 VDD.n2 1.63898
R33 VDD.n11 VDD.n1 1.61022
R34 VDD.n10 VDD.n9 0.266587
R35 VDD.n6 VDD.n5 0.256022
R36 VDD VDD.n0 0.256022
R37 VDD.n12 VDD.n11 0.208674
R38 VDD.n8 VDD.n7 0.174239
R39 VDD.n12 VDD.n0 0.0455
R40 VDD.n7 VDD.n6 0.0451087
R41 VDD.n11 VDD.n10 0.0431522
R42 VDD.n9 VDD.n8 0.040413
R43 GND.n18 GND.n5 38248.4
R44 GND.n18 GND.t6 420.789
R45 GND.t2 GND.n7 420.789
R46 GND.t0 GND.n13 420.789
R47 GND.n13 GND.t4 420.789
R48 GND.t4 GND.n5 420.789
R49 GND.n17 GND.t8 372.896
R50 GND.n14 GND.t9 372.896
R51 GND.t9 GND.t2 321.579
R52 GND.n14 GND.t0 147.106
R53 GND.n16 GND.n15 72.9189
R54 GND.n19 GND.n3 68.6394
R55 GND.n19 GND.n4 68.6394
R56 GND.n8 GND.n0 68.6394
R57 GND.n11 GND.n0 68.6394
R58 GND.n9 GND.n3 47.8338
R59 GND.n9 GND.n8 47.8338
R60 GND.n10 GND.n4 47.8338
R61 GND.n11 GND.n10 47.8338
R62 GND.t6 GND.n17 44.4742
R63 GND.n10 GND.n9 41.6116
R64 GND.n6 GND.n3 20.8061
R65 GND.n6 GND.n4 20.8061
R66 GND.n12 GND.n8 20.8061
R67 GND.n12 GND.n11 20.8061
R68 GND.n25 GND.t5 5.21993
R69 GND.n20 GND.t7 5.20465
R70 GND.n22 GND.t3 5.19995
R71 GND.n23 GND.t1 5.19875
R72 GND.n7 GND.t8 3.42155
R73 GND.n15 GND.n1 2.62021
R74 GND.n16 GND.n2 2.54697
R75 GND.n20 GND.n19 1.9046
R76 GND.n26 GND.n0 1.75394
R77 GND.n6 GND.n2 1.3005
R78 GND.n7 GND.n6 1.3005
R79 GND.n19 GND.n18 1.3005
R80 GND.n12 GND.n1 1.3005
R81 GND.n13 GND.n12 1.3005
R82 GND.n5 GND.n0 1.3005
R83 GND.n17 GND.n16 0.867167
R84 GND.n15 GND.n14 0.867167
R85 GND.n24 GND.n1 0.449144
R86 GND.n21 GND.n2 0.440512
R87 GND GND.n26 0.245557
R88 GND.n23 GND.n22 0.198738
R89 GND.n22 GND.n21 0.151161
R90 GND.n25 GND.n24 0.146403
R91 GND.n26 GND.n25 0.04887
R92 GND.n21 GND.n20 0.0441123
R93 GND.n24 GND.n23 0.0441123
R94 a_4106_n890.t0 a_4106_n890.n0 6.62411
R95 a_4106_n890.n0 a_4106_n890.t2 2.64741
R96 a_4106_n890.n0 a_4106_n890.t1 2.65384
R97 a_3976_38.n1 a_3976_38.t2 0.828482
R98 a_3976_38.n0 a_3976_38.n1 0.653833
R99 a_3976_38.n1 a_3976_38.n5 2.11986
R100 a_3976_38.n5 a_3976_38.n3 4.8366
R101 a_3976_38.n5 a_3976_38.n4 0.321408
R102 a_3976_38.n4 a_3976_38.t4 34.4556
R103 a_3976_38.n4 a_3976_38.t1 33.9516
R104 a_3976_38.n3 a_3976_38.n2 4.77219
R105 a_3976_38.n3 a_3976_38.t0 17.6173
R106 a_3976_38.n2 a_3976_38.t3 1.80318
R107 a_3976_38.n2 a_3976_38.t5 60.685
R108 a_2616_490.t1 a_2616_490.n1 5.05438
R109 a_2616_490.n1 a_2616_490.t2 15.8137
R110 a_2616_490.n1 a_2616_490.n0 0.12795
R111 a_2616_490.n0 a_2616_490.t3 20.0669
R112 a_2616_490.n0 a_2616_490.t0 9.19378
R113 a_2552_398.n0 a_2552_398.n1 0.653833
R114 a_2552_398.n1 a_2552_398.t1 0.847872
R115 a_2552_398.n1 a_2552_398.n3 2.09413
R116 a_2552_398.n3 a_2552_398.n4 4.90175
R117 a_2552_398.n4 a_2552_398.n5 5.15291
R118 a_2552_398.n5 a_2552_398.t4 61.6485
R119 a_2552_398.n5 a_2552_398.t3 1.43204
R120 a_2552_398.n4 a_2552_398.t2 17.5082
R121 a_2552_398.n3 a_2552_398.n2 0.343283
R122 a_2552_398.n2 a_2552_398.t0 33.9534
R123 a_2552_398.n2 a_2552_398.t5 34.4538
C0 INN VDD 0.01057f
C1 INN IB 0.11142f
C2 Q_BAR VDD 0.34321f
C3 INN INP 0.8329f
C4 Q_BAR IB 0.04577f
C5 VDD INP 0.14576f
C6 IB INP 0.02707f
C7 IB GND 2.67149f
C8 INP GND 2.03029f
C9 INN GND 1.71734f
C10 Q_BAR GND 1.61472f
C11 VDD GND 9.57422f
C12 a_2552_398.t1 GND -0.02947f
C13 a_2552_398.n1 GND 0.16556f
C14 a_2552_398.t5 GND 0.16766f
C15 a_2552_398.t0 GND 0.16041f
C16 a_2552_398.n2 GND 0.25429f
C17 a_2552_398.n3 GND 0.07588f
C18 a_2552_398.t2 GND 0.58334f
C19 a_2552_398.n4 GND 1.84466f
C20 a_2552_398.t3 GND 0.21829f
C21 a_2552_398.n5 GND 0.50953f
C22 a_2552_398.t4 GND 0.19726f
C23 a_2616_490.t1 GND 0.06958f
C24 a_2616_490.n0 GND 0.57799f
C25 a_2616_490.t3 GND 0.3668f
C26 a_2616_490.t0 GND 0.14415f
C27 a_2616_490.n1 GND 0.78816f
C28 a_2616_490.t2 GND 0.34324f
C29 a_3976_38.t2 GND -0.03096f
C30 a_3976_38.n1 GND 0.16928f
C31 a_3976_38.n2 GND 0.51936f
C32 a_3976_38.t5 GND 0.2694f
C33 a_3976_38.t3 GND 0.27455f
C34 a_3976_38.t0 GND 0.5543f
C35 a_3976_38.n3 GND 1.71199f
C36 a_3976_38.t1 GND 0.09712f
C37 a_3976_38.t4 GND 0.16819f
C38 a_3976_38.n4 GND 0.25547f
C39 a_3976_38.n5 GND 0.05995f
C40 a_4106_n890.t0 GND 0.09738f
C41 a_4106_n890.t1 GND 0.11221f
C42 a_4106_n890.t2 GND 0.11196f
C43 a_4106_n890.n0 GND 0.50711f
C44 VDD.t9 GND 0.02395f
C45 VDD.t1 GND 0.02295f
C46 VDD.n0 GND 0.14413f
C47 VDD.n1 GND 0.44585f
C48 VDD.t11 GND 0.06766f
C49 VDD.t7 GND 0.0677f
C50 VDD.t10 GND 0.43688f
C51 VDD.t6 GND 0.43688f
C52 VDD.n2 GND 0.4461f
C53 VDD.n3 GND 0.29991f
C54 VDD.t5 GND 0.02361f
C55 VDD.t3 GND 0.02365f
C56 VDD.t4 GND 0.28093f
C57 VDD.t2 GND 0.28093f
C58 VDD.n4 GND 0.3013f
C59 VDD.n5 GND 0.1999f
C60 VDD.n6 GND 0.14176f
C61 VDD.n7 GND 0.10272f
C62 VDD.n8 GND 0.1072f
C63 VDD.n9 GND 0.16171f
C64 VDD.n10 GND 0.1615f
C65 VDD.n11 GND 0.12167f
C66 VDD.n12 GND 0.1157f
C67 VDD.n13 GND 0.30036f
C68 VDD.t0 GND 0.28093f
C69 VDD.t8 GND 0.28093f
C70 VDD.n14 GND 0.30297f
C71 Q_BAR.t0 GND 0.17528f
C72 Q_BAR.t1 GND 0.20929f
C73 Q_BAR.n0 GND 0.6493f
C74 INN.t0 GND 0.25501f
C75 INP.t0 GND 0.30395f
C76 IB.t2 GND 0.1849f
C77 IB.t1 GND 0.08298f
C78 IB.n0 GND 0.42448f
C79 IB.t0 GND 0.17032f
C80 IB.n1 GND 0.28661f
.ends
