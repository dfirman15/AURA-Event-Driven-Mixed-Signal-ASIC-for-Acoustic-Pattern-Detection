** sch_path: /foss/designs/AURA-Event-Driven-Mixed-Signal-ASIC-for-Acoustic-Pattern-Detection/analog/B04_envelope_detector.sch
.subckt B04_envelope_detector VDD Vin Vout GND
*.PININFO VDD:B GND:B Vin:I Vout:O
M1 VDD Vin Vout GND nfet_03v3 L=1u W=2u nf=1
M2 Vout net1 GND GND nfet_03v3 L=4u W=7u nf=1
XC2 GND Vout cap_mim_2f0fF c_width=10u c_length=10u m=100
M3 net1 net1 GND GND nfet_03v3 L=4u W=1u nf=5
M7 net2 net2 VDD VDD pfet_03v3 L=5u W=1u nf=1
M8 net3 net3 net2 net2 pfet_03v3 L=5u W=1u nf=1
M9 net4 net4 net3 net3 pfet_03v3 L=5u W=1u nf=1
M10 net1 net1 net4 net4 pfet_03v3 L=5u W=1u nf=1
.ends
