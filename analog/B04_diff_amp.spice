** sch_path: /foss/designs/AURA-Event-Driven-Mixed-Signal-ASIC-for-Acoustic-Pattern-Detection/analog/B04_diff_amp.sch
.subckt B04_diff_amp VDD Vo V+ V- Vbias VSS
*.PININFO VDD:B VSS:B V+:I V-:I Vo:O Vbias:I
M1 net1 V+ net2 VSS nfet_03v3 L=4u W=1.1u nf=1
M2 net2 Vbias VSS VSS nfet_03v3 L=4u W=2.2u nf=1
M3 Vo V- net2 VSS nfet_03v3 L=4u W=1.1u nf=1
M4 Vo net1 VDD VDD pfet_03v3 L=4u W=13u nf=1
M5 net1 net1 VDD VDD pfet_03v3 L=4u W=13u nf=1
MDummy VDD VDD VDD VDD pfet_03v3 L=4u W=6.5u nf=1
MDummy1 VDD VDD VDD VDD pfet_03v3 L=4u W=6.5u nf=1
Mdummy2 VSS VSS VSS VSS nfet_03v3 L=4u W=0.55u nf=1
Mdummy3 VSS VSS VSS VSS nfet_03v3 L=4u W=0.55u nf=1
.ends
