* Extracted by KLayout with GF180MCU LVS runset on : 13/08/2026 19:28

.SUBCKT B04_comparator IB Q_BAR INN INP VDD GND
M$1 \$3 \$8 VDD VDD pfet_03v3 L=0.28U W=1.5U AS=0.6509P AD=0.6509P PS=3.88U
+ PD=3.88U
M$2 \$11 \$11 VDD VDD pfet_03v3 L=0.28U W=1.5U AS=0.6509P AD=0.6509P PS=3.88U
+ PD=3.88U
M$3 VDD \$8 \$11 VDD pfet_03v3 L=0.28U W=3.5U AS=1.5179P AD=1.5179P PS=7.88U
+ PD=7.88U
M$4 \$8 \$11 VDD VDD pfet_03v3 L=0.28U W=3.5U AS=1.5179P AD=1.5179P PS=7.88U
+ PD=7.88U
M$5 VDD \$11 Q_BAR VDD pfet_03v3 L=0.28U W=1.5U AS=0.6509P AD=0.6509P PS=3.88U
+ PD=3.88U
M$6 VDD \$8 \$8 VDD pfet_03v3 L=0.28U W=1.5U AS=0.6509P AD=0.6509P PS=3.88U
+ PD=3.88U
M$7 \$11 INP \$4 GND nfet_03v3 L=0.28U W=2U AS=0.86765P AD=0.86765P PS=4.88U
+ PD=4.88U
M$8 IB IB GND GND nfet_03v3 L=0.56U W=1U AS=0.44P AD=0.44P PS=2.88U PD=2.88U
M$9 \$4 IB GND GND nfet_03v3 L=0.56U W=1U AS=0.44P AD=0.44P PS=2.88U PD=2.88U
M$10 \$4 INN \$8 GND nfet_03v3 L=0.28U W=2U AS=0.86765P AD=0.86765P PS=4.88U
+ PD=4.88U
M$11 Q_BAR \$3 GND GND nfet_03v3 L=0.56U W=1U AS=0.44P AD=0.44P PS=2.88U
+ PD=2.88U
M$12 \$3 \$3 GND GND nfet_03v3 L=0.56U W=1U AS=0.44P AD=0.44P PS=2.88U PD=2.88U
.ENDS B04_comparator
