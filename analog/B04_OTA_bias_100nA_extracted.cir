* Extracted by KLayout with GF180MCU LVS runset on : 02/08/2026 15:44

* cell B04_OTA_bias_100nA
* pin Vbias3
* pin VbiasN
* pin VDD
* pin Vbias0
* pin Vbias1
* pin Vbias2
* pin VbiasP
* pin GND
.SUBCKT B04_OTA_bias_100nA Vbias3 VbiasN VDD Vbias0 Vbias1 Vbias2 VbiasP GND
* device instance $1 r0 *1 2.75,-3.5 nfet_03v3
M$1 \$8 Vbias1 GND GND nfet_03v3 L=4U W=1U AS=0.44P AD=0.44P PS=2.88U PD=2.88U
* device instance $2 r0 *1 10.75,-3.5 nfet_03v3
M$2 Vbias1 Vbias2 \$8 GND nfet_03v3 L=4U W=1U AS=0.44P AD=0.44P PS=2.88U
+ PD=2.88U
* device instance $3 r0 *1 26.75,3.25 pfet_03v3
M$3 Vbias0 Vbias3 \$14 VDD pfet_03v3 L=4U W=5U AS=2.2P AD=2.2P PS=10.88U
+ PD=10.88U
* device instance $4 r0 *1 2.75,3.25 pfet_03v3
M$4 Vbias2 VbiasP VDD VDD pfet_03v3 L=4U W=5U AS=2.2P AD=2.2P PS=10.88U
+ PD=10.88U
* device instance $5 r0 *1 18.75,3.25 pfet_03v3
M$5 \$14 Vbias0 VDD VDD pfet_03v3 L=4U W=5U AS=2.2P AD=2.2P PS=10.88U PD=10.88U
* device instance $6 r0 *1 10.75,3.25 pfet_03v3
M$6 Vbias1 GND Vbias2 VDD pfet_03v3 L=4U W=5U AS=2.2P AD=2.2P PS=10.88U
+ PD=10.88U
* device instance $7 r270 *1 21,-8.85 nfet_03v3
M$7 Vbias3 VDD Vbias0 GND nfet_03v3 L=4U W=10U AS=4.4P AD=4.4P PS=20.88U
+ PD=20.88U
* device instance $8 r270 *1 5.4,-8.85 nfet_03v3
M$8 Vbias3 VbiasN GND GND nfet_03v3 L=4U W=10U AS=4.4P AD=4.4P PS=20.88U
+ PD=20.88U
.ENDS B04_OTA_bias_100nA
