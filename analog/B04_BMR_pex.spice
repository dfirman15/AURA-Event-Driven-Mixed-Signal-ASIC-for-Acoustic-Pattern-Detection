* NGSPICE file created from B04_BMR.ext - technology: gf180mcuD

.subckt pfet_03v3_YNZBKP w_n574_n804# a_n488_n674# a_400_n674# a_n400_n718# VSUBS
X0 a_400_n674# a_n400_n718# a_n488_n674# w_n574_n804# pfet_03v3 ad=2.86p pd=13.88u as=2.86p ps=13.88u w=6.5u l=4u
C0 a_n488_n674# w_n574_n804# 0.2404f
C1 a_n400_n718# a_n488_n674# 0.2297f
C2 a_n400_n718# w_n574_n804# 0.69736f
C3 a_400_n674# w_n574_n804# 0.2404f
C4 a_n400_n718# a_400_n674# 0.2297f
C5 a_400_n674# VSUBS 0.22279f
C6 a_n488_n674# VSUBS 0.22279f
C7 a_n400_n718# VSUBS 0.39457f
C8 w_n574_n804# VSUBS 5.53795f
.ends

.subckt nfet_03v3_LT7U5F a_n488_n31# a_n400_n123# a_400_n31# w_n512_n147#
X0 a_400_n31# a_n400_n123# a_n488_n31# w_n512_n147# nfet_03v3 ad=0.242p pd=1.98u as=0.242p ps=1.98u w=0.55u l=4u
C0 a_n400_n123# w_n512_n147# 1.05382f
.ends

.subckt nfet_03v3_LPRCZE a_n488_n196# w_n512_n312# a_400_n196# a_n400_n288#
X0 a_400_n196# a_n400_n288# a_n488_n196# w_n512_n312# nfet_03v3 ad=0.968p pd=5.28u as=0.968p ps=5.28u w=2.2u l=4u
C0 a_400_n196# w_n512_n312# 0.10195f
C1 a_n488_n196# w_n512_n312# 0.10195f
C2 a_n400_n288# w_n512_n312# 1.00525f
.ends

.subckt B04_diff_amp GND Vo Vbias V- w_n1560_660# V+ VDD m1_n240_n310#
XXM5_1 VDD m1_n240_n310# VDD m1_n240_n310# GND pfet_03v3_YNZBKP
Xdummy VDD VDD VDD VDD GND pfet_03v3_YNZBKP
XXM5_2 VDD VDD m1_n240_n310# m1_n240_n310# GND pfet_03v3_YNZBKP
XXM3_1 m1_630_n2010# V- Vo GND nfet_03v3_LT7U5F
XXM3_2 Vo V- m1_630_n2010# GND nfet_03v3_LT7U5F
XXM1_1 m1_n240_n310# V+ m1_630_n2010# GND nfet_03v3_LT7U5F
XXM1_2 m1_630_n2010# V+ m1_n240_n310# GND nfet_03v3_LT7U5F
XXM2 m1_630_n2010# GND GND Vbias nfet_03v3_LPRCZE
Xnfet_03v3_LT7U5F_1 GND GND GND GND nfet_03v3_LT7U5F
Xnfet_03v3_LT7U5F_0 GND GND GND GND nfet_03v3_LT7U5F
XXM4_1 VDD VDD Vo m1_n240_n310# GND pfet_03v3_YNZBKP
XXM4_2 VDD Vo VDD m1_n240_n310# GND pfet_03v3_YNZBKP
Xpfet_03v3_YNZBKP_0 VDD VDD VDD VDD GND pfet_03v3_YNZBKP
R0 Vbias Vbias.n0 4.93583
R1 V- V-.n2 3.84033
R2 V-.n2 V-.n0 2.99957
R3 V-.n2 V-.n1 2.01338
R4 V+.n2 V+.n0 4.53505
R5 V+ V+.n2 2.40901
R6 V+.n2 V+.n1 2.04911
R7 VDD.n5 VDD.n3 11.7482
R8 VDD.n1 VDD.n0 7.44275
R9 VDD.n7 VDD.n6 7.44275
R10 VDD VDD.n1 1.38214
R11 VDD VDD.n7 1.29577
R12 VDD.n3 VDD.n2 0.694595
R13 VDD.n5 VDD.n4 0.643827
R14 VDD.n3 VDD.n1 0.0831125
R15 VDD.n7 VDD.n5 0.0753336
R16 GND.n2 GND.n1 4.64868
R17 GND.n5 GND.n4 4.64107
R18 GND.n2 GND.n0 2.12816
R19 GND.n5 GND.n3 2.12188
R20 GND.n6 GND.n2 2.01437
R21 GND.n6 GND.n5 1.90693
R22 GND GND.n6 0.454056
C0 m1_n240_n310# Vo 0.25617f
C1 Vo V- 0.2855f
C2 m1_630_n2010# V- 1.22415f
C3 Vo V+ 0.37482f
C4 m1_n240_n310# V+ 0.60721f
C5 m1_630_n2010# V+ 0.2803f
C6 V+ V- 0.50631f
C7 VDD Vo 0.36505f
C8 m1_630_n2010# Vbias 0.27017f
C9 VDD m1_n240_n310# 6.33723f
C10 VDD.n0 GND 0.2923f
C11 VDD.n1 GND 0.33283f
C12 VDD.n3 GND 2.71567f
C13 VDD.n5 GND 2.77105f
C14 VDD.n6 GND 0.2923f
C15 VDD.n7 GND 0.32852f
C16 V+.n0 GND 0.26119f
C17 V+.n2 GND 0.55996f
C18 V-.n0 GND 0.21506f
C19 V-.n1 GND 0.14731f
C20 V-.n2 GND 0.47695f
C21 VDD GND 2.27787f
C22 Vbias GND 0.70715f
C23 V+ GND 4.50762f
C24 m1_630_n2010# GND 0.83621f
C25 m1_n240_n310# GND -0.61891f
C26 Vo GND 1.71223f
C27 V- GND 1.00705f
.ends

.subckt pfet_03v3_J76TDP w_n574_n278# a_n488_n100# a_n400_n192# a_400_n100# VSUBS
X0 a_400_n100# a_n400_n192# a_n488_n100# w_n574_n278# pfet_03v3 ad=0.44p pd=2.88u as=0.44p ps=2.88u w=1u l=4u
C0 w_n574_n278# a_n400_n192# 0.85203f
C1 a_n400_n192# VSUBS 0.52046f
C2 w_n574_n278# VSUBS 1.91486f
.ends

.subckt nfet_03v3_6ZW7H2 w_n512_n1092# a_n488_n976# a_400_n976# a_n400_n1068#
X0 a_400_n976# a_n400_n1068# a_n488_n976# w_n512_n1092# nfet_03v3 ad=4.4p pd=20.88u as=4.4p ps=20.88u w=10u l=4u
C0 a_400_n976# a_n488_n976# 0.10176f
C1 a_400_n976# a_n400_n1068# 0.35377f
C2 a_n400_n1068# a_n488_n976# 0.35377f
C3 a_400_n976# w_n512_n1092# 0.40205f
C4 a_n488_n976# w_n512_n1092# 0.40205f
C5 a_n400_n1068# w_n512_n1092# 0.96796f
.ends

.subckt ppolyf_u_1k_2Q22HA a_1000_4100# a_2920_n4222# a_n3800_n4222# a_2440_n4222#
+ a_n3320_n4222# a_n920_4100# a_3880_4100# a_1960_4100# a_2920_4100# a_n1880_4100#
+ a_n4760_4100# a_n2840_4100# a_n3800_4100# a_3400_n4222# a_520_4100# a_n1400_n4222#
+ w_n4996_n4458# a_3880_n4222# a_40_n4222# a_n440_4100# a_n4280_n4222# a_n4760_n4222#
+ a_4360_4100# a_2440_4100# a_1480_4100# a_3400_4100# a_1000_n4222# a_n1880_n4222#
+ a_n2360_4100# a_n4280_4100# a_n440_n4222# a_n920_n4222# a_n1400_4100# a_n3320_4100#
+ a_40_4100# a_4360_n4222# a_520_n4222# a_1960_n4222# a_n2840_n4222# a_1480_n4222#
+ a_n2360_n4222#
X0 a_n3320_4100# a_n3320_n4222# w_n4996_n4458# ppolyf_u_1k r_width=2u r_length=41u
X1 a_n2360_4100# a_n2360_n4222# w_n4996_n4458# ppolyf_u_1k r_width=2u r_length=41u
X2 a_n2840_4100# a_n2840_n4222# w_n4996_n4458# ppolyf_u_1k r_width=2u r_length=41u
X3 a_n1400_4100# a_n1400_n4222# w_n4996_n4458# ppolyf_u_1k r_width=2u r_length=41u
X4 a_1000_4100# a_1000_n4222# w_n4996_n4458# ppolyf_u_1k r_width=2u r_length=41u
X5 a_n1880_4100# a_n1880_n4222# w_n4996_n4458# ppolyf_u_1k r_width=2u r_length=41u
X6 a_520_4100# a_520_n4222# w_n4996_n4458# ppolyf_u_1k r_width=2u r_length=41u
X7 a_4360_4100# a_4360_n4222# w_n4996_n4458# ppolyf_u_1k r_width=2u r_length=41u
X8 a_3880_4100# a_3880_n4222# w_n4996_n4458# ppolyf_u_1k r_width=2u r_length=41u
X9 a_n440_4100# a_n440_n4222# w_n4996_n4458# ppolyf_u_1k r_width=2u r_length=41u
X10 a_n920_4100# a_n920_n4222# w_n4996_n4458# ppolyf_u_1k r_width=2u r_length=41u
X11 a_n4280_4100# a_n4280_n4222# w_n4996_n4458# ppolyf_u_1k r_width=2u r_length=41u
X12 a_40_4100# a_40_n4222# w_n4996_n4458# ppolyf_u_1k r_width=2u r_length=41u
X13 a_n4760_4100# a_n4760_n4222# w_n4996_n4458# ppolyf_u_1k r_width=2u r_length=41u
X14 a_n3800_4100# a_n3800_n4222# w_n4996_n4458# ppolyf_u_1k r_width=2u r_length=41u
X15 a_3400_4100# a_3400_n4222# w_n4996_n4458# ppolyf_u_1k r_width=2u r_length=41u
X16 a_2440_4100# a_2440_n4222# w_n4996_n4458# ppolyf_u_1k r_width=2u r_length=41u
X17 a_2920_4100# a_2920_n4222# w_n4996_n4458# ppolyf_u_1k r_width=2u r_length=41u
X18 a_1480_4100# a_1480_n4222# w_n4996_n4458# ppolyf_u_1k r_width=2u r_length=41u
X19 a_1960_4100# a_1960_n4222# w_n4996_n4458# ppolyf_u_1k r_width=2u r_length=41u
C0 a_4360_n4222# w_n4996_n4458# 0.50375f
C1 a_4360_4100# w_n4996_n4458# 0.50375f
C2 a_3880_n4222# w_n4996_n4458# 0.46703f
C3 a_3880_4100# w_n4996_n4458# 0.46703f
C4 a_3400_n4222# w_n4996_n4458# 0.46628f
C5 a_3400_4100# w_n4996_n4458# 0.46628f
C6 a_2920_n4222# w_n4996_n4458# 0.46577f
C7 a_2920_4100# w_n4996_n4458# 0.46577f
C8 a_2440_n4222# w_n4996_n4458# 0.46576f
C9 a_2440_4100# w_n4996_n4458# 0.46576f
C10 a_1960_n4222# w_n4996_n4458# 0.46576f
C11 a_1960_4100# w_n4996_n4458# 0.46576f
C12 a_1480_n4222# w_n4996_n4458# 0.46576f
C13 a_1480_4100# w_n4996_n4458# 0.46576f
C14 a_1000_n4222# w_n4996_n4458# 0.46576f
C15 a_1000_4100# w_n4996_n4458# 0.46576f
C16 a_520_n4222# w_n4996_n4458# 0.46576f
C17 a_520_4100# w_n4996_n4458# 0.46576f
C18 a_40_n4222# w_n4996_n4458# 0.46576f
C19 a_40_4100# w_n4996_n4458# 0.46576f
C20 a_n440_n4222# w_n4996_n4458# 0.46576f
C21 a_n440_4100# w_n4996_n4458# 0.46576f
C22 a_n920_n4222# w_n4996_n4458# 0.46576f
C23 a_n920_4100# w_n4996_n4458# 0.46576f
C24 a_n1400_n4222# w_n4996_n4458# 0.46576f
C25 a_n1400_4100# w_n4996_n4458# 0.46576f
C26 a_n1880_n4222# w_n4996_n4458# 0.46576f
C27 a_n1880_4100# w_n4996_n4458# 0.46576f
C28 a_n2360_n4222# w_n4996_n4458# 0.46576f
C29 a_n2360_4100# w_n4996_n4458# 0.46576f
C30 a_n2840_n4222# w_n4996_n4458# 0.46576f
C31 a_n2840_4100# w_n4996_n4458# 0.46576f
C32 a_n3320_n4222# w_n4996_n4458# 0.46577f
C33 a_n3320_4100# w_n4996_n4458# 0.46577f
C34 a_n3800_n4222# w_n4996_n4458# 0.46628f
C35 a_n3800_4100# w_n4996_n4458# 0.46628f
C36 a_n4280_n4222# w_n4996_n4458# 0.46703f
C37 a_n4280_4100# w_n4996_n4458# 0.46703f
C38 a_n4760_n4222# w_n4996_n4458# 0.50375f
C39 a_n4760_4100# w_n4996_n4458# 0.50375f
.ends

.subckt cap_mim w_n120_n120# m4_n120_n120# m4_0_0#
X0 m4_0_0# m4_n120_n120# cap_mim_2f0_m4m5_noshield c_width=10u c_length=10u
C0 m4_0_0# m4_n120_n120# 0.59194f
C1 m4_0_0# w_n120_n120# 1.92189f
C2 m4_n120_n120# w_n120_n120# 1.45465f
.ends

.subckt pfet_03v3_LEPL4X w_n4174_n228# a_4000_n50# a_n4000_n142# a_n4088_n50# VSUBS
X0 a_4000_n50# a_n4000_n142# a_n4088_n50# w_n4174_n228# pfet_03v3 ad=0.22p pd=1.88u as=0.22p ps=1.88u w=0.5u l=40u
C0 a_n4000_n142# w_n4174_n228# 7.5821f
C1 a_n4000_n142# VSUBS 4.7326f
C2 w_n4174_n228# VSUBS 11.4201f
.ends

.subckt nfet_03v3_V3BJRC a_n188_n100# a_n100_n192# a_100_n100# w_n212_n216#
X0 a_100_n100# a_n100_n192# a_n188_n100# w_n212_n216# nfet_03v3 ad=0.44p pd=2.88u as=0.44p ps=2.88u w=1u l=1u
C0 a_n100_n192# w_n212_n216# 0.40813f
.ends

.subckt nfet_03v3_QHJDE5 a_n188_n1976# a_n100_n2068# w_n350_n2186# a_100_n1976#
X0 a_100_n1976# a_n100_n2068# a_n188_n1976# w_n350_n2186# nfet_03v3 ad=8.8p pd=40.88u as=8.8p ps=40.88u w=20u l=1u
C0 a_n188_n1976# a_n100_n2068# 0.42696f
C1 a_100_n1976# a_n100_n2068# 0.42696f
C2 a_100_n1976# a_n188_n1976# 0.71572f
C3 a_100_n1976# w_n350_n2186# 2.16744f
C4 a_n188_n1976# w_n350_n2186# 2.16744f
C5 a_n100_n2068# w_n350_n2186# 0.54891f
.ends

.subckt nfet_03v3_D2LTTM a_n940_n976# w_n964_n1092# a_n52_n976# a_52_n1068# a_852_n976#
+ a_n852_n1068#
X0 a_852_n976# a_52_n1068# a_n52_n976# w_n964_n1092# nfet_03v3 ad=4.4p pd=20.88u as=2.6p ps=10.52u w=10u l=4u
X1 a_n52_n976# a_n852_n1068# a_n940_n976# w_n964_n1092# nfet_03v3 ad=2.6p pd=10.52u as=4.4p ps=20.88u w=10u l=4u
C0 a_n940_n976# a_n52_n976# 0.10176f
C1 a_852_n976# a_n52_n976# 0.10176f
C2 a_n940_n976# a_n852_n1068# 0.35377f
C3 a_n52_n976# a_n852_n1068# 0.35377f
C4 a_852_n976# a_52_n1068# 0.35377f
C5 a_n52_n976# a_52_n1068# 0.35377f
C6 a_852_n976# w_n964_n1092# 0.40205f
C7 a_n940_n976# w_n964_n1092# 0.40205f
C8 a_52_n1068# w_n964_n1092# 0.94492f
C9 a_n852_n1068# w_n964_n1092# 0.94492f
.ends

.subckt B04_BMR VDD GND VbiasP VbiasN
XB04_diff_amp_0 GND VbiasP VbiasN VbiasN GND B04_diff_amp_0/V+ VDD B04_diff_amp_0/m1_n240_n310#
+ B04_diff_amp
Xdummy VDD VDD VDD VDD GND pfet_03v3_J76TDP
Xnfet_03v3_6ZW7H2_0 GND GND GND GND nfet_03v3_6ZW7H2
Xnfet_03v3_6ZW7H2_1 GND GND GND GND nfet_03v3_6ZW7H2
XXM3_1 VDD VDD VbiasP B04_diff_amp_0/V+ GND pfet_03v3_J76TDP
XXM3_2 VDD B04_diff_amp_0/V+ VbiasP VDD GND pfet_03v3_J76TDP
XXR2 m1_5550_10240# m1_6990_1850# m1_270_1850# m1_6990_1850# m1_1230_1850# m1_3630_10240#
+ m1_8430_10240# m1_6510_10240# m1_7470_10240# m1_2670_10240# m1_n210_10240# m1_1710_10240#
+ m1_750_10240# m1_7950_1850# m1_4590_10240# m1_3150_1850# GND m1_7950_1850# m1_4110_1850#
+ m1_3630_10240# m1_270_1850# m1_n13920_7340# m1_8430_10240# m1_6510_10240# m1_5550_10240#
+ m1_7470_10240# m1_5070_1850# m1_2190_1850# m1_1710_10240# m1_n210_10240# m1_4110_1850#
+ m1_3150_1850# m1_2670_10240# m1_750_10240# m1_4590_10240# GND m1_5070_1850# m1_6030_1850#
+ m1_1230_1850# m1_6030_1850# m1_2190_1850# ppolyf_u_1k_2Q22HA
Xcap_mim_0[0] GND VbiasN VbiasP cap_mim
Xcap_mim_0[1] GND VbiasN VbiasP cap_mim
Xcap_mim_0[2] GND VbiasN VbiasP cap_mim
Xcap_mim_0[3] GND VbiasN VbiasP cap_mim
Xcap_mim_0[4] GND VbiasN VbiasP cap_mim
Xcap_mim_0[5] GND VbiasN VbiasP cap_mim
Xcap_mim_0[6] GND VbiasN VbiasP cap_mim
Xcap_mim_0[7] GND VbiasN VbiasP cap_mim
Xpfet_03v3_J76TDP_0 VDD VDD VDD VDD GND pfet_03v3_J76TDP
Xcap_mim_1[0] GND VbiasN VbiasP cap_mim
Xcap_mim_1[1] GND VbiasN VbiasP cap_mim
Xcap_mim_1[2] GND VbiasN VbiasP cap_mim
Xcap_mim_1[3] GND VbiasN VbiasP cap_mim
Xcap_mim_1[4] GND VbiasN VbiasP cap_mim
Xcap_mim_1[5] GND VbiasN VbiasP cap_mim
Xcap_mim_1[6] GND VbiasN VbiasP cap_mim
Xcap_mim_1[7] GND VbiasN VbiasP cap_mim
Xcap_mim_1[8] GND VbiasN VbiasP cap_mim
Xcap_mim_1[9] GND VbiasN VbiasP cap_mim
Xcap_mim_1[10] GND VbiasN VbiasP cap_mim
Xcap_mim_1[11] GND VbiasN VbiasP cap_mim
XXM1 VDD VDD m1_n15420_9660# m1_n15420_9660# GND pfet_03v3_LEPL4X
XXM4 VbiasN m1_n16340_7940# VbiasP GND nfet_03v3_V3BJRC
XXM5 GND VbiasN GND m1_n16340_7940# nfet_03v3_QHJDE5
XXM6 GND VbiasN GND VbiasN nfet_03v3_6ZW7H2
XXM9 VDD m1_n7420_9600# m1_n16340_7940# m1_n16340_7940# GND pfet_03v3_LEPL4X
XXM8 VDD m1_n7420_9600# m1_n7420_9600# m1_n15420_9660# GND pfet_03v3_LEPL4X
XXM2_1 VDD VbiasN VbiasP VDD GND pfet_03v3_J76TDP
XXM2_2 VDD VDD VbiasP VbiasN GND pfet_03v3_J76TDP
XXM7_2 m1_n13920_7340# GND B04_diff_amp_0/V+ VbiasN m1_n13920_7340# VbiasN nfet_03v3_D2LTTM
XXM7_1 m1_n13920_7340# GND B04_diff_amp_0/V+ VbiasN m1_n13920_7340# VbiasN nfet_03v3_D2LTTM
R0 VbiasP.n45 VbiasP.n44 7.89265
R1 VbiasP VbiasP.n37 7.23837
R2 VbiasP.n45 VbiasP 4.0855
R3 VbiasP.n40 VbiasP.n38 2.11858
R4 VbiasP.n42 VbiasP.n41 2.08115
R5 VbiasP.n44 VbiasP.n43 1.21341
R6 VbiasP.n40 VbiasP.n39 1.21325
R7 VbiasP.n42 VbiasP.n40 0.764609
R8 VbiasP.n15 VbiasP.n13 0.160449
R9 VbiasP.n2 VbiasP.n0 0.160449
R10 VbiasP.n30 VbiasP.n28 0.160449
R11 VbiasP.n25 VbiasP.n23 0.160449
R12 VbiasP.n37 VbiasP.n22 0.126426
R13 VbiasP.n17 VbiasP.n15 0.123259
R14 VbiasP.n19 VbiasP.n17 0.123259
R15 VbiasP.n21 VbiasP.n19 0.123259
R16 VbiasP.n4 VbiasP.n2 0.123259
R17 VbiasP.n6 VbiasP.n4 0.123259
R18 VbiasP.n8 VbiasP.n6 0.123259
R19 VbiasP.n10 VbiasP.n8 0.123259
R20 VbiasP.n12 VbiasP.n10 0.123259
R21 VbiasP.n32 VbiasP.n30 0.123259
R22 VbiasP.n34 VbiasP.n32 0.123259
R23 VbiasP.n36 VbiasP.n34 0.123259
R24 VbiasP.n27 VbiasP.n25 0.123259
R25 VbiasP.n22 VbiasP.n12 0.111159
R26 VbiasP.n37 VbiasP.n27 0.110959
R27 VbiasP VbiasP.n45 0.0655
R28 VbiasP.n44 VbiasP.n42 0.0479559
R29 VbiasP.n15 VbiasP.n14 0.0376901
R30 VbiasP.n17 VbiasP.n16 0.0376901
R31 VbiasP.n19 VbiasP.n18 0.0376901
R32 VbiasP.n2 VbiasP.n1 0.0376901
R33 VbiasP.n4 VbiasP.n3 0.0376901
R34 VbiasP.n6 VbiasP.n5 0.0376901
R35 VbiasP.n8 VbiasP.n7 0.0376901
R36 VbiasP.n10 VbiasP.n9 0.0376901
R37 VbiasP.n12 VbiasP.n11 0.0376901
R38 VbiasP.n21 VbiasP.n20 0.0376901
R39 VbiasP.n30 VbiasP.n29 0.0376901
R40 VbiasP.n32 VbiasP.n31 0.0376901
R41 VbiasP.n34 VbiasP.n33 0.0376901
R42 VbiasP.n25 VbiasP.n24 0.0376901
R43 VbiasP.n27 VbiasP.n26 0.0376901
R44 VbiasP.n36 VbiasP.n35 0.0376901
R45 VbiasP.n37 VbiasP.n36 0.0128
R46 VbiasP.n22 VbiasP.n21 0.0126
R47 VbiasN.n17 VbiasN.n15 86.8429
R48 VbiasN.n9 VbiasN.n7 11.2635
R49 VbiasN.n17 VbiasN.n16 10.6365
R50 VbiasN.n14 VbiasN.n13 10.6365
R51 VbiasN.n11 VbiasN.n10 10.6365
R52 VbiasN.n9 VbiasN.n8 10.6365
R53 VbiasN.n5 VbiasN.n4 4.42856
R54 VbiasN VbiasN.n18 4.35932
R55 VbiasN.n2 VbiasN.n0 2.99957
R56 VbiasN.n3 VbiasN.n2 2.38748
R57 VbiasN.n2 VbiasN.n1 2.01338
R58 VbiasN VbiasN 1.64618
R59 VbiasN.n3 VbiasN 1.45336
R60 VbiasN.n12 VbiasN.n6 0.788582
R61 VbiasN.n11 VbiasN.n9 0.746965
R62 VbiasN.n5 VbiasN.n3 0.620364
R63 VbiasN.n14 VbiasN.n12 0.491502
R64 VbiasN VbiasN.n5 0.432693
R65 VbiasN.n18 VbiasN.n14 0.276391
R66 VbiasN.n12 VbiasN.n11 0.201336
R67 VbiasN.n18 VbiasN.n17 0.15852
R68 VDD.n21 VDD.n20 478.527
R69 VDD.n20 VDD.n19 13.4803
R70 VDD.n12 VDD.n5 11.7361
R71 VDD.n18 VDD.n17 7.44275
R72 VDD.n16 VDD.n15 7.44275
R73 VDD.n10 VDD.n9 4.54039
R74 VDD.n20 VDD 4.49632
R75 VDD.n22 VDD.n0 4.42785
R76 VDD.n24 VDD.n0 4.42417
R77 VDD.n11 VDD.n10 4.4205
R78 VDD.n22 VDD.n21 3.10258
R79 VDD.n23 VDD.n2 1.21376
R80 VDD.n9 VDD.n8 1.21325
R81 VDD.n7 VDD.n6 0.68469
R82 VDD.n5 VDD.n4 0.643827
R83 VDD.n13 VDD.n11 0.483986
R84 VDD VDD.n16 0.438864
R85 VDD.n18 VDD 0.412408
R86 VDD.n13 VDD.n12 0.213732
R87 VDD.n9 VDD.n3 0.100556
R88 VDD.n12 VDD.n7 0.0822845
R89 VDD.n14 VDD.n7 0.0657684
R90 VDD.n14 VDD.n13 0.0558279
R91 VDD.n19 VDD.n5 0.046991
R92 VDD.n24 VDD.n23 0.0416959
R93 VDD.n23 VDD.n22 0.0409536
R94 VDD.n21 VDD.n3 0.0256866
R95 VDD VDD.n1 0.023
R96 VDD.n24 VDD.n1 0.0205
R97 VDD.n19 VDD.n18 0.0145164
R98 VDD VDD.n24 0.0144175
R99 VDD.n1 VDD 0.0105
R100 VDD.n16 VDD.n14 0.00554098
R101 VDD.n11 VDD.n3 0.00117164
R102 GND.n26 GND.n25 275519
R103 GND.n25 GND.n6 86277
R104 GND.n14 GND.n7 2588.85
R105 GND.n28 GND.n27 2439.08
R106 GND.n24 GND.n8 678.097
R107 GND.n29 GND.n5 368.2
R108 GND.n16 GND.n15 272.014
R109 GND.n28 GND.n6 219.297
R110 GND.n27 GND.n26 155.404
R111 GND.n25 GND.n7 37.8375
R112 GND.n13 GND.n8 35.5773
R113 GND.n14 GND.n6 33.8547
R114 GND.n8 GND.n0 32.4475
R115 GND.n25 GND.n24 19.2807
R116 GND.n30 GND.n4 15.5919
R117 GND.n34 GND.n32 10.6383
R118 GND.n38 GND.n37 10.6365
R119 GND.n13 GND.n12 9.88336
R120 GND.n21 GND.n20 9.54208
R121 GND.n22 GND.n21 9.27868
R122 GND.n11 GND.n10 4.64107
R123 GND.n35 GND.n34 4.60009
R124 GND.n39 GND.n2 2.31454
R125 GND.n11 GND.n9 2.12188
R126 GND.n20 GND.n19 2.01338
R127 GND.n4 GND.n2 2.01264
R128 GND.n36 GND.n3 1.94214
R129 GND GND.n0 1.16012
R130 GND GND.n40 1.02685
R131 GND.n31 GND.n3 0.945604
R132 GND.n40 GND.n1 0.939071
R133 GND.n26 GND.n2 0.727368
R134 GND.n34 GND.n33 0.720657
R135 GND.n31 GND.n30 0.624071
R136 GND.n17 GND.n16 0.3255
R137 GND.n16 GND.n7 0.3255
R138 GND.n15 GND.n1 0.3255
R139 GND.n15 GND.n14 0.3255
R140 GND.n12 GND.n1 0.309071
R141 GND.n20 GND.n18 0.214916
R142 GND.n17 GND.n0 0.208007
R143 GND.n12 GND.n11 0.204944
R144 GND.n40 GND 0.175308
R145 GND.n30 GND.n29 0.158076
R146 GND.n29 GND.n28 0.158076
R147 GND.n5 GND.n4 0.158076
R148 GND.n27 GND.n5 0.158076
R149 GND.n23 GND.n13 0.0999102
R150 GND GND.n39 0.0835769
R151 GND.n18 GND.n17 0.0721622
R152 GND.n24 GND.n23 0.0716475
R153 GND.n39 GND.n38 0.0338333
R154 GND.n38 GND.n36 0.03325
R155 GND.n36 GND.n35 0.0256667
R156 GND.n22 GND.n18 0.0111166
R157 GND.n35 GND.n31 0.0100833
R158 GND.n23 GND.n22 0.00218901
C0 VDD VbiasP 4.89325f
C1 VbiasN VDD 1.73163f
C2 m1_n7420_9600# VDD -0.13705f
C3 VbiasN B04_diff_amp_0/m1_n240_n310# 0.53227f
C4 B04_diff_amp_0/m1_n240_n310# VbiasP 0.56066f
C5 m1_n16340_7940# VDD 5.42532f
C6 B04_diff_amp_0/V+ VDD 0.87726f
C7 B04_diff_amp_0/V+ B04_diff_amp_0/m1_n240_n310# 0.85574f
C8 m1_n7420_9600# m1_n15420_9660# 5.73163f
C9 VbiasN VbiasP 7.6121f
C10 m1_n13920_7340# VbiasP 0.80784f
C11 VbiasN m1_n13920_7340# 4.72457f
C12 VbiasN m1_n16340_7940# 0.5504f
C13 m1_n16340_7940# VbiasP 0.22218f
C14 m1_n7420_9600# m1_n16340_7940# 5.72886f
C15 m1_n13920_7340# m1_n16340_7940# 0.25014f
C16 VDD m1_n15420_9660# 6.12979f
C17 B04_diff_amp_0/V+ VbiasP 1.21366f
C18 VbiasN B04_diff_amp_0/V+ 2.82026f
C19 m1_n13920_7340# B04_diff_amp_0/V+ 0.30082f
C20 VDD.n5 GND 1.40084f
C21 VDD.n12 GND 1.37857f
C22 VDD.n15 GND 0.15172f
C23 VDD.n16 GND 0.20882f
C24 VDD.n17 GND 0.15172f
C25 VDD.n18 GND 0.20552f
C26 VDD.n19 GND 0.18665f
C27 VDD.n20 GND 2.37365f
C28 VDD.n21 GND 2.27902f
C29 VDD.n22 GND 0.1802f
C30 VDD.n23 GND 0.10624f
C31 VbiasN.n3 GND 0.11243f
C32 VbiasN.n7 GND 0.14331f
C33 VbiasN.n8 GND 0.14001f
C34 VbiasN.n9 GND 0.11677f
C35 VbiasN.n10 GND 0.14001f
C36 VbiasN.n13 GND 0.14001f
C37 VbiasN.n16 GND 0.14001f
C38 VbiasN.n17 GND 0.12145f
C39 m1_n7420_9600# GND -1.04144f
C40 m1_n16340_7940# GND 4.42758f
C41 m1_n15420_9660# GND -0.91719f
C42 VbiasP GND 1.45521f
C43 VbiasN GND 8.75753f
C44 m1_8430_10240# GND 0.17473f
C45 m1_7950_1850# GND 0.21733f
C46 m1_7470_10240# GND 0.155f
C47 m1_6990_1850# GND 0.17304f
C48 m1_6510_10240# GND 0.1553f
C49 m1_6030_1850# GND 0.17304f
C50 m1_5550_10240# GND 0.15542f
C51 m1_5070_1850# GND 0.17304f
C52 m1_4590_10240# GND 0.1553f
C53 m1_4110_1850# GND 0.17304f
C54 m1_3630_10240# GND 0.13855f
C55 m1_3150_1850# GND 0.17304f
C56 m1_2670_10240# GND 0.1553f
C57 m1_2190_1850# GND 0.17304f
C58 m1_1710_10240# GND 0.1553f
C59 m1_1230_1850# GND 0.17304f
C60 m1_750_10240# GND 0.155f
C61 m1_270_1850# GND 0.17829f
C62 m1_n13920_7340# GND 9.87614f
C63 m1_n210_10240# GND 0.16988f
C64 VDD GND -37.47621f
C65 B04_diff_amp_0/V+ GND 1.03842f
C66 B04_diff_amp_0/m1_630_n2010# GND -0.53413f
C67 B04_diff_amp_0/m1_n240_n310# GND -2.00341f
.ends
