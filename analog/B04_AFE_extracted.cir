* Extracted by KLayout with GF180MCU LVS runset on : 24/08/2026 14:43

.SUBCKT B04_AFE VDD05 Vin Vout cap0 cap1 cap2 SUB
X$51 Vin \$7 \$14 \$11 SUB B04_LNAv2
X$63 \$7 \$12 VDD05 B04_coupling
X$69 \$11 \$16 \$14 SUB B04_BMR
C$1 SUB Vout 2e-11 cap_mim_2f0fF A=10000P P=4000U
C$101 SUB SUB 3.84e-11 cap_mim_2f0fF A=19200P P=7680U
C$130 \$I1153 \$I1152 8e-12 cap_mim_2f0fF A=4000P P=1600U
C$134 \$I1155 \$I1154 2e-12 cap_mim_2f0fF A=1000P P=400U
C$159 \$I1160 \$I1154 4e-12 cap_mim_2f0fF A=2000P P=800U
C$206 SUB \$I1154 1e-11 cap_mim_2f0fF A=5000P P=2000U
C$228 SUB \$I1152 1e-11 cap_mim_2f0fF A=5000P P=2000U
C$326 \$I1329 \$I1154 8e-12 cap_mim_2f0fF A=4000P P=1600U
C$348 \$I1354 \$I1152 4e-12 cap_mim_2f0fF A=2000P P=800U
C$397 \$I1403 \$I1152 2e-12 cap_mim_2f0fF A=1000P P=400U
C$428 \$I1494 \$41 4e-12 cap_mim_2f0fF A=2000P P=800U
C$434 \$I1494 \$28 2e-13 cap_mim_2f0fF A=100P P=40U
C$487 \$I1521 \$I1513 2e-12 cap_mim_2f0fF A=1000P P=400U
C$490 \$I1526 \$I1519 8e-12 cap_mim_2f0fF A=4000P P=1600U
C$513 \$I1522 \$I1513 4e-12 cap_mim_2f0fF A=2000P P=800U
C$561 SUB \$I1513 1e-11 cap_mim_2f0fF A=5000P P=2000U
C$584 SUB \$I1519 1e-11 cap_mim_2f0fF A=5000P P=2000U
C$689 \$I1523 \$I1513 8e-12 cap_mim_2f0fF A=4000P P=1600U
C$708 \$I1525 \$I1519 4e-12 cap_mim_2f0fF A=2000P P=800U
C$754 \$I1524 \$I1519 2e-12 cap_mim_2f0fF A=1000P P=400U
M$794 Vout \$28 \$14 SUB nfet_03v3 L=1U W=2U AS=0.88P AD=0.88P PS=4.88U PD=4.88U
M$795 \$I1126 \$16 Vout SUB nfet_03v3 L=4U W=0.5U AS=0.22P AD=0.22P PS=1.88U
+ PD=1.88U
M$796 \$I1116 \$16 \$I1120 SUB nfet_03v3 L=4U W=0.5U AS=0.22P AD=0.22P PS=1.88U
+ PD=1.88U
M$797 \$I1116 \$16 \$I1125 SUB nfet_03v3 L=4U W=0.5U AS=0.22P AD=0.22P PS=1.88U
+ PD=1.88U
M$798 SUB \$16 \$I1120 SUB nfet_03v3 L=4U W=0.5U AS=0.22P AD=0.22P PS=1.88U
+ PD=1.88U
M$799 \$I1126 \$16 \$I1125 SUB nfet_03v3 L=4U W=0.5U AS=0.22P AD=0.22P PS=1.88U
+ PD=1.88U
M$800 \$28 \$28 \$I1494 \$I1494 pfet_03v3 L=4U W=0.5U AS=0.22P AD=0.22P
+ PS=1.88U PD=1.88U
M$801 \$28 \$I1494 \$I1494 \$28 pfet_03v3 L=4U W=0.5U AS=0.22P AD=0.22P
+ PS=1.88U PD=1.88U
M$802 SUB cap2 \$I1153 SUB nfet_03v3 L=1U W=0.5U AS=0.22P AD=0.22P PS=1.88U
+ PD=1.88U
M$803 SUB cap0 \$I1155 SUB nfet_03v3 L=1U W=0.5U AS=0.22P AD=0.22P PS=1.88U
+ PD=1.88U
M$804 SUB cap1 \$I1160 SUB nfet_03v3 L=1U W=0.5U AS=0.22P AD=0.22P PS=1.88U
+ PD=1.88U
M$805 SUB cap2 \$I1329 SUB nfet_03v3 L=1U W=0.5U AS=0.22P AD=0.22P PS=1.88U
+ PD=1.88U
M$806 SUB cap1 \$I1354 SUB nfet_03v3 L=1U W=0.5U AS=0.22P AD=0.22P PS=1.88U
+ PD=1.88U
M$807 SUB cap0 \$I1403 SUB nfet_03v3 L=1U W=0.5U AS=0.22P AD=0.22P PS=1.88U
+ PD=1.88U
M$808 SUB cap0 \$I1521 SUB nfet_03v3 L=1U W=0.5U AS=0.22P AD=0.22P PS=1.88U
+ PD=1.88U
M$809 SUB cap0 \$I1524 SUB nfet_03v3 L=1U W=0.5U AS=0.22P AD=0.22P PS=1.88U
+ PD=1.88U
M$810 SUB cap1 \$I1522 SUB nfet_03v3 L=1U W=0.5U AS=0.22P AD=0.22P PS=1.88U
+ PD=1.88U
M$811 SUB cap1 \$I1525 SUB nfet_03v3 L=1U W=0.5U AS=0.22P AD=0.22P PS=1.88U
+ PD=1.88U
M$812 SUB cap2 \$I1523 SUB nfet_03v3 L=1U W=0.5U AS=0.22P AD=0.22P PS=1.88U
+ PD=1.88U
M$813 SUB cap2 \$I1526 SUB nfet_03v3 L=1U W=0.5U AS=0.22P AD=0.22P PS=1.88U
+ PD=1.88U
M$814 \$I16285 \$I1490 \$42 \$42 pfet_03v3 L=4U W=5U AS=1.75P AD=1.75P PS=8.9U
+ PD=8.9U
M$816 \$I16295 \$I1499 \$42 \$42 pfet_03v3 L=4U W=5U AS=1.75P AD=1.75P PS=8.9U
+ PD=8.9U
M$818 \$I16305 \$I1489 \$42 \$42 pfet_03v3 L=4U W=5U AS=1.75P AD=1.75P PS=8.9U
+ PD=8.9U
M$820 \$I16315 \$I1488 \$42 \$42 pfet_03v3 L=4U W=5U AS=1.75P AD=1.75P PS=8.9U
+ PD=8.9U
M$822 \$I16325 \$I1491 \$42 \$42 pfet_03v3 L=4U W=5U AS=1.75P AD=1.75P PS=8.9U
+ PD=8.9U
M$824 \$I16335 \$I1491 \$42 \$42 pfet_03v3 L=4U W=5U AS=1.75P AD=1.75P PS=8.9U
+ PD=8.9U
M$826 \$I16345 \$I1489 \$42 \$42 pfet_03v3 L=4U W=5U AS=1.75P AD=1.75P PS=8.9U
+ PD=8.9U
M$828 \$I16355 \$I1488 \$42 \$42 pfet_03v3 L=4U W=5U AS=1.75P AD=1.75P PS=8.9U
+ PD=8.9U
M$830 \$I16365 \$I1490 \$42 \$42 pfet_03v3 L=4U W=5U AS=1.75P AD=1.75P PS=8.9U
+ PD=8.9U
M$832 \$I1154 \$I1485 \$I16286 \$42 pfet_03v3 L=4U W=5U AS=2.2P AD=2.2P
+ PS=11.76U PD=11.76U
M$834 \$42 \$I16284 \$I16286 \$42 pfet_03v3 L=4U W=5U AS=2.2P AD=2.2P PS=11.76U
+ PD=11.76U
M$835 \$42 \$I16284 \$I16287 \$42 pfet_03v3 L=4U W=5U AS=2.2P AD=2.2P PS=11.76U
+ PD=11.76U
M$838 \$I16287 \$I1485 \$I16284 \$42 pfet_03v3 L=4U W=5U AS=2.2P AD=2.2P
+ PS=11.76U PD=11.76U
M$840 \$42 \$42 \$42 \$42 pfet_03v3 L=4U W=90U AS=39.6P AD=39.6P PS=211.68U
+ PD=211.68U
M$844 \$28 \$I1493 \$I16296 \$42 pfet_03v3 L=4U W=5U AS=2.2P AD=2.2P PS=11.76U
+ PD=11.76U
M$846 \$42 \$I16294 \$I16296 \$42 pfet_03v3 L=4U W=5U AS=2.2P AD=2.2P PS=11.76U
+ PD=11.76U
M$847 \$42 \$I16294 \$I16297 \$42 pfet_03v3 L=4U W=5U AS=2.2P AD=2.2P PS=11.76U
+ PD=11.76U
M$850 \$I16297 \$I1493 \$I16294 \$42 pfet_03v3 L=4U W=5U AS=2.2P AD=2.2P
+ PS=11.76U PD=11.76U
M$856 \$I1152 \$I1483 \$I16306 \$42 pfet_03v3 L=4U W=5U AS=2.2P AD=2.2P
+ PS=11.76U PD=11.76U
M$858 \$42 \$I16304 \$I16306 \$42 pfet_03v3 L=4U W=5U AS=2.2P AD=2.2P PS=11.76U
+ PD=11.76U
M$859 \$42 \$I16304 \$I16307 \$42 pfet_03v3 L=4U W=5U AS=2.2P AD=2.2P PS=11.76U
+ PD=11.76U
M$862 \$I16307 \$I1483 \$I16304 \$42 pfet_03v3 L=4U W=5U AS=2.2P AD=2.2P
+ PS=11.76U PD=11.76U
M$868 \$I1152 \$I1481 \$I16316 \$42 pfet_03v3 L=4U W=5U AS=2.2P AD=2.2P
+ PS=11.76U PD=11.76U
M$870 \$42 \$I16314 \$I16316 \$42 pfet_03v3 L=4U W=5U AS=2.2P AD=2.2P PS=11.76U
+ PD=11.76U
M$871 \$42 \$I16314 \$I16317 \$42 pfet_03v3 L=4U W=5U AS=2.2P AD=2.2P PS=11.76U
+ PD=11.76U
M$874 \$I16317 \$I1481 \$I16314 \$42 pfet_03v3 L=4U W=5U AS=2.2P AD=2.2P
+ PS=11.76U PD=11.76U
M$880 \$I1152 \$I1487 \$I16326 \$42 pfet_03v3 L=4U W=5U AS=2.2P AD=2.2P
+ PS=11.76U PD=11.76U
M$882 \$42 \$I16324 \$I16326 \$42 pfet_03v3 L=4U W=5U AS=2.2P AD=2.2P PS=11.76U
+ PD=11.76U
M$883 \$42 \$I16324 \$I16327 \$42 pfet_03v3 L=4U W=5U AS=2.2P AD=2.2P PS=11.76U
+ PD=11.76U
M$886 \$I16327 \$I1487 \$I16324 \$42 pfet_03v3 L=4U W=5U AS=2.2P AD=2.2P
+ PS=11.76U PD=11.76U
M$892 \$I1513 \$I1487 \$I16336 \$42 pfet_03v3 L=4U W=5U AS=2.2P AD=2.2P
+ PS=11.76U PD=11.76U
M$894 \$42 \$I16334 \$I16336 \$42 pfet_03v3 L=4U W=5U AS=2.2P AD=2.2P PS=11.76U
+ PD=11.76U
M$895 \$42 \$I16334 \$I16337 \$42 pfet_03v3 L=4U W=5U AS=2.2P AD=2.2P PS=11.76U
+ PD=11.76U
M$898 \$I16337 \$I1487 \$I16334 \$42 pfet_03v3 L=4U W=5U AS=2.2P AD=2.2P
+ PS=11.76U PD=11.76U
M$904 \$I1513 \$I1483 \$I16346 \$42 pfet_03v3 L=4U W=5U AS=2.2P AD=2.2P
+ PS=11.76U PD=11.76U
M$906 \$42 \$I16344 \$I16346 \$42 pfet_03v3 L=4U W=5U AS=2.2P AD=2.2P PS=11.76U
+ PD=11.76U
M$907 \$42 \$I16344 \$I16347 \$42 pfet_03v3 L=4U W=5U AS=2.2P AD=2.2P PS=11.76U
+ PD=11.76U
M$910 \$I16347 \$I1483 \$I16344 \$42 pfet_03v3 L=4U W=5U AS=2.2P AD=2.2P
+ PS=11.76U PD=11.76U
M$916 \$I1513 \$I1481 \$I16356 \$42 pfet_03v3 L=4U W=5U AS=2.2P AD=2.2P
+ PS=11.76U PD=11.76U
M$918 \$42 \$I16354 \$I16356 \$42 pfet_03v3 L=4U W=5U AS=2.2P AD=2.2P PS=11.76U
+ PD=11.76U
M$919 \$42 \$I16354 \$I16357 \$42 pfet_03v3 L=4U W=5U AS=2.2P AD=2.2P PS=11.76U
+ PD=11.76U
M$922 \$I16357 \$I1481 \$I16354 \$42 pfet_03v3 L=4U W=5U AS=2.2P AD=2.2P
+ PS=11.76U PD=11.76U
M$928 \$I1519 \$I1485 \$I16366 \$42 pfet_03v3 L=4U W=5U AS=2.2P AD=2.2P
+ PS=11.76U PD=11.76U
M$930 \$42 \$I16364 \$I16366 \$42 pfet_03v3 L=4U W=5U AS=2.2P AD=2.2P PS=11.76U
+ PD=11.76U
M$931 \$42 \$I16364 \$I16367 \$42 pfet_03v3 L=4U W=5U AS=2.2P AD=2.2P PS=11.76U
+ PD=11.76U
M$934 \$I16367 \$I1485 \$I16364 \$42 pfet_03v3 L=4U W=5U AS=2.2P AD=2.2P
+ PS=11.76U PD=11.76U
M$940 \$I16281 \$41 \$I16285 \$42 pfet_03v3 L=1U W=2U AS=0.61P AD=0.61P
+ PS=4.94U PD=4.94U
M$944 \$I16283 \$I1152 \$I16285 \$42 pfet_03v3 L=1U W=2U AS=0.61P AD=0.61P
+ PS=4.94U PD=4.94U
M$948 \$I16291 \$I1494 \$I16295 \$42 pfet_03v3 L=1U W=2U AS=0.61P AD=0.61P
+ PS=4.94U PD=4.94U
M$952 \$I16293 \$I1152 \$I16295 \$42 pfet_03v3 L=1U W=2U AS=0.61P AD=0.61P
+ PS=4.94U PD=4.94U
M$956 \$I16301 \$I1152 \$I16305 \$42 pfet_03v3 L=1U W=2U AS=0.61P AD=0.61P
+ PS=4.94U PD=4.94U
M$960 \$I16303 \$41 \$I16305 \$42 pfet_03v3 L=1U W=2U AS=0.61P AD=0.61P
+ PS=4.94U PD=4.94U
M$964 \$I16311 \$41 \$I16315 \$42 pfet_03v3 L=1U W=2U AS=0.61P AD=0.61P
+ PS=4.94U PD=4.94U
M$968 \$I16313 \$I1513 \$I16315 \$42 pfet_03v3 L=1U W=2U AS=0.61P AD=0.61P
+ PS=4.94U PD=4.94U
M$972 \$I16321 \$I1154 \$I16325 \$42 pfet_03v3 L=1U W=2U AS=0.61P AD=0.61P
+ PS=4.94U PD=4.94U
M$976 \$I16323 \$41 \$I16325 \$42 pfet_03v3 L=1U W=2U AS=0.61P AD=0.61P
+ PS=4.94U PD=4.94U
M$980 \$I16331 \$I1519 \$I16335 \$42 pfet_03v3 L=1U W=2U AS=0.61P AD=0.61P
+ PS=4.94U PD=4.94U
M$984 \$I16333 \$41 \$I16335 \$42 pfet_03v3 L=1U W=2U AS=0.61P AD=0.61P
+ PS=4.94U PD=4.94U
M$988 \$I16341 \$I1513 \$I16345 \$42 pfet_03v3 L=1U W=2U AS=0.61P AD=0.61P
+ PS=4.94U PD=4.94U
M$992 \$I16343 \$41 \$I16345 \$42 pfet_03v3 L=1U W=2U AS=0.61P AD=0.61P
+ PS=4.94U PD=4.94U
M$996 \$I16351 \$41 \$I16355 \$42 pfet_03v3 L=1U W=2U AS=0.61P AD=0.61P
+ PS=4.94U PD=4.94U
M$1000 \$I16353 \$12 \$I16355 \$42 pfet_03v3 L=1U W=2U AS=0.61P AD=0.61P
+ PS=4.94U PD=4.94U
M$1004 \$I16361 \$41 \$I16365 \$42 pfet_03v3 L=1U W=2U AS=0.61P AD=0.61P
+ PS=4.94U PD=4.94U
M$1008 \$I16363 \$I1513 \$I16365 \$42 pfet_03v3 L=1U W=2U AS=0.61P AD=0.61P
+ PS=4.94U PD=4.94U
M$1012 \$I16279 \$I1152 \$I16285 \$42 pfet_03v3 L=1U W=2U AS=0.61P AD=0.61P
+ PS=4.94U PD=4.94U
M$1016 \$I16280 \$41 \$I16285 \$42 pfet_03v3 L=1U W=2U AS=0.61P AD=0.61P
+ PS=4.94U PD=4.94U
M$1020 \$I16289 \$I1152 \$I16295 \$42 pfet_03v3 L=1U W=2U AS=0.61P AD=0.61P
+ PS=4.94U PD=4.94U
M$1024 \$I16290 \$I1494 \$I16295 \$42 pfet_03v3 L=1U W=2U AS=0.61P AD=0.61P
+ PS=4.94U PD=4.94U
M$1028 \$I16299 \$41 \$I16305 \$42 pfet_03v3 L=1U W=2U AS=0.61P AD=0.61P
+ PS=4.94U PD=4.94U
M$1032 \$I16300 \$I1152 \$I16305 \$42 pfet_03v3 L=1U W=2U AS=0.61P AD=0.61P
+ PS=4.94U PD=4.94U
M$1036 \$I16309 \$I1513 \$I16315 \$42 pfet_03v3 L=1U W=2U AS=0.61P AD=0.61P
+ PS=4.94U PD=4.94U
M$1040 \$I16310 \$41 \$I16315 \$42 pfet_03v3 L=1U W=2U AS=0.61P AD=0.61P
+ PS=4.94U PD=4.94U
M$1044 \$I16319 \$41 \$I16325 \$42 pfet_03v3 L=1U W=2U AS=0.61P AD=0.61P
+ PS=4.94U PD=4.94U
M$1048 \$I16320 \$I1154 \$I16325 \$42 pfet_03v3 L=1U W=2U AS=0.61P AD=0.61P
+ PS=4.94U PD=4.94U
M$1052 \$I16329 \$41 \$I16335 \$42 pfet_03v3 L=1U W=2U AS=0.61P AD=0.61P
+ PS=4.94U PD=4.94U
M$1056 \$I16330 \$I1519 \$I16335 \$42 pfet_03v3 L=1U W=2U AS=0.61P AD=0.61P
+ PS=4.94U PD=4.94U
M$1060 \$I16339 \$41 \$I16345 \$42 pfet_03v3 L=1U W=2U AS=0.61P AD=0.61P
+ PS=4.94U PD=4.94U
M$1064 \$I16340 \$I1513 \$I16345 \$42 pfet_03v3 L=1U W=2U AS=0.61P AD=0.61P
+ PS=4.94U PD=4.94U
M$1068 \$I16349 \$12 \$I16355 \$42 pfet_03v3 L=1U W=2U AS=0.61P AD=0.61P
+ PS=4.94U PD=4.94U
M$1072 \$I16350 \$41 \$I16355 \$42 pfet_03v3 L=1U W=2U AS=0.61P AD=0.61P
+ PS=4.94U PD=4.94U
M$1076 \$I16359 \$I1513 \$I16365 \$42 pfet_03v3 L=1U W=2U AS=0.61P AD=0.61P
+ PS=4.94U PD=4.94U
M$1080 \$I16360 \$41 \$I16365 \$42 pfet_03v3 L=1U W=2U AS=0.61P AD=0.61P
+ PS=4.94U PD=4.94U
M$1084 \$42 \$42 \$42 \$42 pfet_03v3 L=1U W=18U AS=7.92P AD=7.92P PS=67.68U
+ PD=67.68U
M$1120 \$I16278 \$I1478 \$I16281 SUB nfet_03v3 L=1U W=2U AS=0.88P AD=0.88P
+ PS=5.76U PD=5.76U
M$1121 \$I16283 \$I1478 \$I16282 SUB nfet_03v3 L=1U W=2U AS=0.88P AD=0.88P
+ PS=5.76U PD=5.76U
M$1122 SUB SUB SUB SUB nfet_03v3 L=1U W=36U AS=15.84P AD=15.84P PS=103.68U
+ PD=103.68U
M$1124 \$I16288 \$I1492 \$I16291 SUB nfet_03v3 L=1U W=2U AS=0.88P AD=0.88P
+ PS=5.76U PD=5.76U
M$1125 \$I16293 \$I1492 \$I16292 SUB nfet_03v3 L=1U W=2U AS=0.88P AD=0.88P
+ PS=5.76U PD=5.76U
M$1128 \$I16298 \$I1477 \$I16301 SUB nfet_03v3 L=1U W=2U AS=0.88P AD=0.88P
+ PS=5.76U PD=5.76U
M$1129 \$I16303 \$I1477 \$I16302 SUB nfet_03v3 L=1U W=2U AS=0.88P AD=0.88P
+ PS=5.76U PD=5.76U
M$1132 \$I16308 \$I1476 \$I16311 SUB nfet_03v3 L=1U W=2U AS=0.88P AD=0.88P
+ PS=5.76U PD=5.76U
M$1133 \$I16313 \$I1476 \$I16312 SUB nfet_03v3 L=1U W=2U AS=0.88P AD=0.88P
+ PS=5.76U PD=5.76U
M$1136 \$I16318 \$I1479 \$I16321 SUB nfet_03v3 L=1U W=2U AS=0.88P AD=0.88P
+ PS=5.76U PD=5.76U
M$1137 \$I16323 \$I1479 \$I16322 SUB nfet_03v3 L=1U W=2U AS=0.88P AD=0.88P
+ PS=5.76U PD=5.76U
M$1140 \$I16328 \$I1479 \$I16331 SUB nfet_03v3 L=1U W=2U AS=0.88P AD=0.88P
+ PS=5.76U PD=5.76U
M$1141 \$I16333 \$I1479 \$I16332 SUB nfet_03v3 L=1U W=2U AS=0.88P AD=0.88P
+ PS=5.76U PD=5.76U
M$1144 \$I16338 \$I1477 \$I16341 SUB nfet_03v3 L=1U W=2U AS=0.88P AD=0.88P
+ PS=5.76U PD=5.76U
M$1145 \$I16343 \$I1477 \$I16342 SUB nfet_03v3 L=1U W=2U AS=0.88P AD=0.88P
+ PS=5.76U PD=5.76U
M$1148 \$I16348 \$I1476 \$I16351 SUB nfet_03v3 L=1U W=2U AS=0.88P AD=0.88P
+ PS=5.76U PD=5.76U
M$1149 \$I16353 \$I1476 \$I16352 SUB nfet_03v3 L=1U W=2U AS=0.88P AD=0.88P
+ PS=5.76U PD=5.76U
M$1152 \$I16358 \$I1478 \$I16361 SUB nfet_03v3 L=1U W=2U AS=0.88P AD=0.88P
+ PS=5.76U PD=5.76U
M$1153 \$I16363 \$I1478 \$I16362 SUB nfet_03v3 L=1U W=2U AS=0.88P AD=0.88P
+ PS=5.76U PD=5.76U
M$1192 SUB \$I16281 \$I16278 SUB nfet_03v3 L=4U W=1U AS=0.44P AD=0.44P PS=3.76U
+ PD=3.76U
M$1193 \$I16279 \$I1484 SUB SUB nfet_03v3 L=4U W=1U AS=0.44P AD=0.44P PS=3.76U
+ PD=3.76U
M$1194 \$I16279 \$I16281 SUB SUB nfet_03v3 L=4U W=1U AS=0.44P AD=0.44P PS=3.76U
+ PD=3.76U
M$1195 SUB \$I16283 \$I16280 SUB nfet_03v3 L=4U W=1U AS=0.44P AD=0.44P PS=3.76U
+ PD=3.76U
M$1196 SUB \$I1484 \$I16280 SUB nfet_03v3 L=4U W=1U AS=0.44P AD=0.44P PS=3.76U
+ PD=3.76U
M$1197 \$I16282 \$I16283 SUB SUB nfet_03v3 L=4U W=1U AS=0.44P AD=0.44P PS=3.76U
+ PD=3.76U
M$1198 SUB SUB SUB SUB nfet_03v3 L=4U W=27U AS=11.88P AD=11.88P PS=101.52U
+ PD=101.52U
M$1200 SUB \$I16291 \$I16288 SUB nfet_03v3 L=4U W=1U AS=0.44P AD=0.44P PS=3.76U
+ PD=3.76U
M$1201 \$I16289 \$I1500 SUB SUB nfet_03v3 L=4U W=1U AS=0.44P AD=0.44P PS=3.76U
+ PD=3.76U
M$1202 \$I16289 \$I16291 SUB SUB nfet_03v3 L=4U W=1U AS=0.44P AD=0.44P PS=3.76U
+ PD=3.76U
M$1203 SUB \$I16293 \$I16290 SUB nfet_03v3 L=4U W=1U AS=0.44P AD=0.44P PS=3.76U
+ PD=3.76U
M$1204 SUB \$I1500 \$I16290 SUB nfet_03v3 L=4U W=1U AS=0.44P AD=0.44P PS=3.76U
+ PD=3.76U
M$1205 \$I16292 \$I16293 SUB SUB nfet_03v3 L=4U W=1U AS=0.44P AD=0.44P PS=3.76U
+ PD=3.76U
M$1208 SUB \$I16301 \$I16298 SUB nfet_03v3 L=4U W=1U AS=0.44P AD=0.44P PS=3.76U
+ PD=3.76U
M$1209 \$I16299 \$I1482 SUB SUB nfet_03v3 L=4U W=1U AS=0.44P AD=0.44P PS=3.76U
+ PD=3.76U
M$1210 \$I16299 \$I16301 SUB SUB nfet_03v3 L=4U W=1U AS=0.44P AD=0.44P PS=3.76U
+ PD=3.76U
M$1211 SUB \$I16303 \$I16300 SUB nfet_03v3 L=4U W=1U AS=0.44P AD=0.44P PS=3.76U
+ PD=3.76U
M$1212 SUB \$I1482 \$I16300 SUB nfet_03v3 L=4U W=1U AS=0.44P AD=0.44P PS=3.76U
+ PD=3.76U
M$1213 \$I16302 \$I16303 SUB SUB nfet_03v3 L=4U W=1U AS=0.44P AD=0.44P PS=3.76U
+ PD=3.76U
M$1216 SUB \$I16311 \$I16308 SUB nfet_03v3 L=4U W=1U AS=0.44P AD=0.44P PS=3.76U
+ PD=3.76U
M$1217 \$I16309 \$I1480 SUB SUB nfet_03v3 L=4U W=1U AS=0.44P AD=0.44P PS=3.76U
+ PD=3.76U
M$1218 \$I16309 \$I16311 SUB SUB nfet_03v3 L=4U W=1U AS=0.44P AD=0.44P PS=3.76U
+ PD=3.76U
M$1219 SUB \$I16313 \$I16310 SUB nfet_03v3 L=4U W=1U AS=0.44P AD=0.44P PS=3.76U
+ PD=3.76U
M$1220 SUB \$I1480 \$I16310 SUB nfet_03v3 L=4U W=1U AS=0.44P AD=0.44P PS=3.76U
+ PD=3.76U
M$1221 \$I16312 \$I16313 SUB SUB nfet_03v3 L=4U W=1U AS=0.44P AD=0.44P PS=3.76U
+ PD=3.76U
M$1224 SUB \$I16321 \$I16318 SUB nfet_03v3 L=4U W=1U AS=0.44P AD=0.44P PS=3.76U
+ PD=3.76U
M$1225 \$I16319 \$I1486 SUB SUB nfet_03v3 L=4U W=1U AS=0.44P AD=0.44P PS=3.76U
+ PD=3.76U
M$1226 \$I16319 \$I16321 SUB SUB nfet_03v3 L=4U W=1U AS=0.44P AD=0.44P PS=3.76U
+ PD=3.76U
M$1227 SUB \$I16323 \$I16320 SUB nfet_03v3 L=4U W=1U AS=0.44P AD=0.44P PS=3.76U
+ PD=3.76U
M$1228 SUB \$I1486 \$I16320 SUB nfet_03v3 L=4U W=1U AS=0.44P AD=0.44P PS=3.76U
+ PD=3.76U
M$1229 \$I16322 \$I16323 SUB SUB nfet_03v3 L=4U W=1U AS=0.44P AD=0.44P PS=3.76U
+ PD=3.76U
M$1232 SUB \$I16331 \$I16328 SUB nfet_03v3 L=4U W=1U AS=0.44P AD=0.44P PS=3.76U
+ PD=3.76U
M$1233 \$I16329 \$I1486 SUB SUB nfet_03v3 L=4U W=1U AS=0.44P AD=0.44P PS=3.76U
+ PD=3.76U
M$1234 \$I16329 \$I16331 SUB SUB nfet_03v3 L=4U W=1U AS=0.44P AD=0.44P PS=3.76U
+ PD=3.76U
M$1235 SUB \$I16333 \$I16330 SUB nfet_03v3 L=4U W=1U AS=0.44P AD=0.44P PS=3.76U
+ PD=3.76U
M$1236 SUB \$I1486 \$I16330 SUB nfet_03v3 L=4U W=1U AS=0.44P AD=0.44P PS=3.76U
+ PD=3.76U
M$1237 \$I16332 \$I16333 SUB SUB nfet_03v3 L=4U W=1U AS=0.44P AD=0.44P PS=3.76U
+ PD=3.76U
M$1240 SUB \$I16341 \$I16338 SUB nfet_03v3 L=4U W=1U AS=0.44P AD=0.44P PS=3.76U
+ PD=3.76U
M$1241 \$I16339 \$I1482 SUB SUB nfet_03v3 L=4U W=1U AS=0.44P AD=0.44P PS=3.76U
+ PD=3.76U
M$1242 \$I16339 \$I16341 SUB SUB nfet_03v3 L=4U W=1U AS=0.44P AD=0.44P PS=3.76U
+ PD=3.76U
M$1243 SUB \$I16343 \$I16340 SUB nfet_03v3 L=4U W=1U AS=0.44P AD=0.44P PS=3.76U
+ PD=3.76U
M$1244 SUB \$I1482 \$I16340 SUB nfet_03v3 L=4U W=1U AS=0.44P AD=0.44P PS=3.76U
+ PD=3.76U
M$1245 \$I16342 \$I16343 SUB SUB nfet_03v3 L=4U W=1U AS=0.44P AD=0.44P PS=3.76U
+ PD=3.76U
M$1248 SUB \$I16351 \$I16348 SUB nfet_03v3 L=4U W=1U AS=0.44P AD=0.44P PS=3.76U
+ PD=3.76U
M$1249 \$I16349 \$I1480 SUB SUB nfet_03v3 L=4U W=1U AS=0.44P AD=0.44P PS=3.76U
+ PD=3.76U
M$1250 \$I16349 \$I16351 SUB SUB nfet_03v3 L=4U W=1U AS=0.44P AD=0.44P PS=3.76U
+ PD=3.76U
M$1251 SUB \$I16353 \$I16350 SUB nfet_03v3 L=4U W=1U AS=0.44P AD=0.44P PS=3.76U
+ PD=3.76U
M$1252 SUB \$I1480 \$I16350 SUB nfet_03v3 L=4U W=1U AS=0.44P AD=0.44P PS=3.76U
+ PD=3.76U
M$1253 \$I16352 \$I16353 SUB SUB nfet_03v3 L=4U W=1U AS=0.44P AD=0.44P PS=3.76U
+ PD=3.76U
M$1256 SUB \$I16361 \$I16358 SUB nfet_03v3 L=4U W=1U AS=0.44P AD=0.44P PS=3.76U
+ PD=3.76U
M$1257 \$I16359 \$I1484 SUB SUB nfet_03v3 L=4U W=1U AS=0.44P AD=0.44P PS=3.76U
+ PD=3.76U
M$1258 \$I16359 \$I16361 SUB SUB nfet_03v3 L=4U W=1U AS=0.44P AD=0.44P PS=3.76U
+ PD=3.76U
M$1259 SUB \$I16363 \$I16360 SUB nfet_03v3 L=4U W=1U AS=0.44P AD=0.44P PS=3.76U
+ PD=3.76U
M$1260 SUB \$I1484 \$I16360 SUB nfet_03v3 L=4U W=1U AS=0.44P AD=0.44P PS=3.76U
+ PD=3.76U
M$1261 \$I16362 \$I16363 SUB SUB nfet_03v3 L=4U W=1U AS=0.44P AD=0.44P PS=3.76U
+ PD=3.76U
M$1265 \$I16279 \$I1478 \$I16284 SUB nfet_03v3 L=4U W=1U AS=0.44P AD=0.44P
+ PS=3.76U PD=3.76U
M$1271 \$I16280 \$I1478 \$I1154 SUB nfet_03v3 L=4U W=1U AS=0.44P AD=0.44P
+ PS=3.76U PD=3.76U
M$1279 \$I16289 \$I1492 \$I16294 SUB nfet_03v3 L=4U W=1U AS=0.44P AD=0.44P
+ PS=3.76U PD=3.76U
M$1285 \$I16290 \$I1492 \$28 SUB nfet_03v3 L=4U W=1U AS=0.44P AD=0.44P PS=3.76U
+ PD=3.76U
M$1293 \$I16299 \$I1477 \$I16304 SUB nfet_03v3 L=4U W=1U AS=0.44P AD=0.44P
+ PS=3.76U PD=3.76U
M$1299 \$I16300 \$I1477 \$I1152 SUB nfet_03v3 L=4U W=1U AS=0.44P AD=0.44P
+ PS=3.76U PD=3.76U
M$1307 \$I16309 \$I1476 \$I16314 SUB nfet_03v3 L=4U W=1U AS=0.44P AD=0.44P
+ PS=3.76U PD=3.76U
M$1313 \$I16310 \$I1476 \$I1152 SUB nfet_03v3 L=4U W=1U AS=0.44P AD=0.44P
+ PS=3.76U PD=3.76U
M$1321 \$I16319 \$I1479 \$I16324 SUB nfet_03v3 L=4U W=1U AS=0.44P AD=0.44P
+ PS=3.76U PD=3.76U
M$1327 \$I16320 \$I1479 \$I1152 SUB nfet_03v3 L=4U W=1U AS=0.44P AD=0.44P
+ PS=3.76U PD=3.76U
M$1335 \$I16329 \$I1479 \$I16334 SUB nfet_03v3 L=4U W=1U AS=0.44P AD=0.44P
+ PS=3.76U PD=3.76U
M$1341 \$I16330 \$I1479 \$I1513 SUB nfet_03v3 L=4U W=1U AS=0.44P AD=0.44P
+ PS=3.76U PD=3.76U
M$1349 \$I16339 \$I1477 \$I16344 SUB nfet_03v3 L=4U W=1U AS=0.44P AD=0.44P
+ PS=3.76U PD=3.76U
M$1355 \$I16340 \$I1477 \$I1513 SUB nfet_03v3 L=4U W=1U AS=0.44P AD=0.44P
+ PS=3.76U PD=3.76U
M$1363 \$I16349 \$I1476 \$I16354 SUB nfet_03v3 L=4U W=1U AS=0.44P AD=0.44P
+ PS=3.76U PD=3.76U
M$1369 \$I16350 \$I1476 \$I1513 SUB nfet_03v3 L=4U W=1U AS=0.44P AD=0.44P
+ PS=3.76U PD=3.76U
M$1377 \$I16359 \$I1478 \$I16364 SUB nfet_03v3 L=4U W=1U AS=0.44P AD=0.44P
+ PS=3.76U PD=3.76U
M$1383 \$I16360 \$I1478 \$I1519 SUB nfet_03v3 L=4U W=1U AS=0.44P AD=0.44P
+ PS=3.76U PD=3.76U
M$1390 \$I1492 \$11 \$42 \$42 pfet_03v3 L=4U W=25U AS=11P AD=11P PS=50.88U
+ PD=50.88U
M$1391 \$I1493 \$29 SUB SUB nfet_03v3 L=4U W=50U AS=22P AD=22P PS=100.88U
+ PD=100.88U
M$1392 \$I1478 \$11 \$42 \$42 pfet_03v3 L=4U W=2U AS=0.88P AD=0.88P PS=4.88U
+ PD=4.88U
M$1393 \$I1479 \$11 \$42 \$42 pfet_03v3 L=4U W=2U AS=0.88P AD=0.88P PS=4.88U
+ PD=4.88U
M$1394 \$I1485 \$29 SUB SUB nfet_03v3 L=4U W=4U AS=1.76P AD=1.76P PS=8.88U
+ PD=8.88U
M$1395 \$I1487 \$29 SUB SUB nfet_03v3 L=4U W=4U AS=1.76P AD=1.76P PS=8.88U
+ PD=8.88U
M$1396 \$I1476 \$11 \$42 \$42 pfet_03v3 L=4U W=1.25U AS=0.55P AD=0.55P PS=3.38U
+ PD=3.38U
M$1397 \$I1477 \$11 \$42 \$42 pfet_03v3 L=4U W=1.25U AS=0.55P AD=0.55P PS=3.38U
+ PD=3.38U
M$1398 \$I1481 \$29 SUB SUB nfet_03v3 L=4U W=2.5U AS=1.1P AD=1.1P PS=5.88U
+ PD=5.88U
M$1399 \$I1483 \$29 SUB SUB nfet_03v3 L=4U W=2.5U AS=1.1P AD=1.1P PS=5.88U
+ PD=5.88U
M$1400 \$I16368 \$I1500 SUB SUB nfet_03v3 L=4U W=1U AS=0.44P AD=0.44P PS=2.88U
+ PD=2.88U
M$1401 \$I1500 \$I1492 \$I16368 SUB nfet_03v3 L=4U W=1U AS=0.44P AD=0.44P
+ PS=2.88U PD=2.88U
M$1402 \$I1484 \$I1478 \$I16370 SUB nfet_03v3 L=4U W=1U AS=0.44P AD=0.44P
+ PS=2.88U PD=2.88U
M$1403 \$I16370 \$I1484 SUB SUB nfet_03v3 L=4U W=1U AS=0.44P AD=0.44P PS=2.88U
+ PD=2.88U
M$1404 \$I1486 \$I1479 \$I16372 SUB nfet_03v3 L=4U W=1U AS=0.44P AD=0.44P
+ PS=2.88U PD=2.88U
M$1405 \$I16372 \$I1486 SUB SUB nfet_03v3 L=4U W=1U AS=0.44P AD=0.44P PS=2.88U
+ PD=2.88U
M$1406 \$I1480 \$I1476 \$I16374 SUB nfet_03v3 L=4U W=1U AS=0.44P AD=0.44P
+ PS=2.88U PD=2.88U
M$1407 \$I16374 \$I1480 SUB SUB nfet_03v3 L=4U W=1U AS=0.44P AD=0.44P PS=2.88U
+ PD=2.88U
M$1408 \$I1482 \$I1477 \$I16376 SUB nfet_03v3 L=4U W=1U AS=0.44P AD=0.44P
+ PS=2.88U PD=2.88U
M$1409 \$I16376 \$I1482 SUB SUB nfet_03v3 L=4U W=1U AS=0.44P AD=0.44P PS=2.88U
+ PD=2.88U
M$1410 \$I1493 \$42 \$I1499 SUB nfet_03v3 L=4U W=10U AS=4.4P AD=4.4P PS=20.88U
+ PD=20.88U
M$1411 \$I1485 \$42 \$I1490 SUB nfet_03v3 L=4U W=10U AS=4.4P AD=4.4P PS=20.88U
+ PD=20.88U
M$1412 \$I1487 \$42 \$I1491 SUB nfet_03v3 L=4U W=10U AS=4.4P AD=4.4P PS=20.88U
+ PD=20.88U
M$1413 \$I1481 \$42 \$I1488 SUB nfet_03v3 L=4U W=10U AS=4.4P AD=4.4P PS=20.88U
+ PD=20.88U
M$1414 \$I1483 \$42 \$I1489 SUB nfet_03v3 L=4U W=10U AS=4.4P AD=4.4P PS=20.88U
+ PD=20.88U
M$1415 \$I1499 \$I1493 \$I16369 \$42 pfet_03v3 L=4U W=5U AS=2.2P AD=2.2P
+ PS=10.88U PD=10.88U
M$1416 \$I16369 \$I1499 \$42 \$42 pfet_03v3 L=4U W=5U AS=2.2P AD=2.2P PS=10.88U
+ PD=10.88U
M$1417 \$I1500 SUB \$I1492 \$42 pfet_03v3 L=4U W=5U AS=2.2P AD=2.2P PS=10.88U
+ PD=10.88U
M$1418 \$I1490 \$I1485 \$I16371 \$42 pfet_03v3 L=4U W=5U AS=2.2P AD=2.2P
+ PS=10.88U PD=10.88U
M$1419 \$I16371 \$I1490 \$42 \$42 pfet_03v3 L=4U W=5U AS=2.2P AD=2.2P PS=10.88U
+ PD=10.88U
M$1420 \$I1484 SUB \$I1478 \$42 pfet_03v3 L=4U W=5U AS=2.2P AD=2.2P PS=10.88U
+ PD=10.88U
M$1421 \$I1491 \$I1487 \$I16373 \$42 pfet_03v3 L=4U W=5U AS=2.2P AD=2.2P
+ PS=10.88U PD=10.88U
M$1422 \$I16373 \$I1491 \$42 \$42 pfet_03v3 L=4U W=5U AS=2.2P AD=2.2P PS=10.88U
+ PD=10.88U
M$1423 \$I1486 SUB \$I1479 \$42 pfet_03v3 L=4U W=5U AS=2.2P AD=2.2P PS=10.88U
+ PD=10.88U
M$1424 \$I1488 \$I1481 \$I16375 \$42 pfet_03v3 L=4U W=5U AS=2.2P AD=2.2P
+ PS=10.88U PD=10.88U
M$1425 \$I16375 \$I1488 \$42 \$42 pfet_03v3 L=4U W=5U AS=2.2P AD=2.2P PS=10.88U
+ PD=10.88U
M$1426 \$I1480 SUB \$I1476 \$42 pfet_03v3 L=4U W=5U AS=2.2P AD=2.2P PS=10.88U
+ PD=10.88U
M$1427 \$I1489 \$I1483 \$I16377 \$42 pfet_03v3 L=4U W=5U AS=2.2P AD=2.2P
+ PS=10.88U PD=10.88U
M$1428 \$I16377 \$I1489 \$42 \$42 pfet_03v3 L=4U W=5U AS=2.2P AD=2.2P PS=10.88U
+ PD=10.88U
M$1429 \$I1482 SUB \$I1477 \$42 pfet_03v3 L=4U W=5U AS=2.2P AD=2.2P PS=10.88U
+ PD=10.88U
.ENDS B04_AFE

.SUBCKT B04_LNAv2 Vin Vout VDD VbiasP GND
C$1 \$8 Vin 4e-12 cap_mim_2f0fF A=2000P P=800U
C$20 Vout \$8 2e-13 cap_mim_2f0fF A=100P P=40U
M$22 VDD VbiasP Vout VDD pfet_03v3 L=4U W=40U AS=17.6P AD=17.6P PS=115.2U
+ PD=115.2U
M$62 Vout Vout \$8 \$8 pfet_03v3 L=20U W=1U AS=0.44P AD=0.44P PS=2.88U PD=2.88U
M$63 Vout \$8 \$8 Vout pfet_03v3 L=20U W=1U AS=0.44P AD=0.44P PS=2.88U PD=2.88U
M$64 Vout \$8 GND GND nfet_03v3 L=1U W=400U AS=111.2P AD=111.2P PS=495.6U
+ PD=495.6U
.ENDS B04_LNAv2

.SUBCKT B04_coupling Vin Vout VDD05
C$1 Vout Vin 4e-12 cap_mim_2f0fF A=2000P P=800U
M$21 VDD05 Vout Vout VDD05 pfet_03v3 L=4U W=0.5U AS=0.22P AD=0.22P PS=1.88U
+ PD=1.88U
M$22 VDD05 VDD05 Vout Vout pfet_03v3 L=4U W=0.5U AS=0.22P AD=0.22P PS=1.88U
+ PD=1.88U
.ENDS B04_coupling

.SUBCKT B04_BMR VbiasP VbiasN VDD GND
X$4 VbiasN \$60 VbiasN VbiasP VDD GND B04_diff_amp
C$1 VbiasN VbiasP 4e-12 cap_mim_2f0fF A=2000P P=800U
M$21 \$64 VbiasN GND GND nfet_03v3 L=1U W=20U AS=8.8P AD=8.8P PS=40.88U
+ PD=40.88U
R$22 GND \$26 GND 410000 ppolyf_u_1k L=820U W=2U
M$42 VbiasP \$64 VbiasN GND nfet_03v3 L=1U W=1U AS=0.44P AD=0.44P PS=2.88U
+ PD=2.88U
M$43 \$73 \$64 \$64 VDD pfet_03v3 L=40U W=0.5U AS=0.22P AD=0.22P PS=1.88U
+ PD=1.88U
M$44 VDD \$72 \$72 VDD pfet_03v3 L=40U W=0.5U AS=0.22P AD=0.22P PS=1.88U
+ PD=1.88U
M$45 \$73 \$73 \$72 VDD pfet_03v3 L=40U W=0.5U AS=0.22P AD=0.22P PS=1.88U
+ PD=1.88U
M$46 VDD VbiasP VbiasN VDD pfet_03v3 L=4U W=2U AS=0.88P AD=0.88P PS=5.76U
+ PD=5.76U
M$48 \$60 VbiasP VDD VDD pfet_03v3 L=4U W=2U AS=0.88P AD=0.88P PS=5.76U PD=5.76U
M$50 VDD VDD VDD VDD pfet_03v3 L=4U W=2U AS=0.88P AD=0.88P PS=5.76U PD=5.76U
M$52 GND VbiasN VbiasN GND nfet_03v3 L=4U W=10U AS=4.4P AD=4.4P PS=20.88U
+ PD=20.88U
M$53 GND GND GND GND nfet_03v3 L=4U W=20U AS=8.8P AD=8.8P PS=41.76U PD=41.76U
M$55 \$60 VbiasN \$26 GND nfet_03v3 L=4U W=40U AS=14P AD=14P PS=62.8U PD=62.8U
.ENDS B04_BMR

.SUBCKT B04_diff_amp Vbias V+ V\x2d Vo VDD GND
M$1 VDD \$7 \$7 VDD pfet_03v3 L=4U W=13U AS=5.72P AD=5.72P PS=27.76U PD=27.76U
M$3 VDD \$7 Vo VDD pfet_03v3 L=4U W=13U AS=5.72P AD=5.72P PS=27.76U PD=27.76U
M$5 VDD VDD VDD VDD pfet_03v3 L=4U W=13U AS=5.72P AD=5.72P PS=27.76U PD=27.76U
M$7 GND Vbias \$4 GND nfet_03v3 L=4U W=2.2U AS=0.968P AD=0.968P PS=5.28U
+ PD=5.28U
M$8 \$7 V+ \$4 GND nfet_03v3 L=4U W=1.1U AS=0.484P AD=0.484P PS=3.96U PD=3.96U
M$10 \$4 V\x2d Vo GND nfet_03v3 L=4U W=1.1U AS=0.484P AD=0.484P PS=3.96U
+ PD=3.96U
M$12 GND GND GND GND nfet_03v3 L=4U W=1.1U AS=0.484P AD=0.484P PS=3.96U PD=3.96U
.ENDS B04_diff_amp
