* Extracted by KLayout with GF180MCU LVS runset on : 13/08/2026 05:01

.SUBCKT B04_TOP VDD VbiasP|Vo Vbias2 Vin|Vin+|Vout Vbias3 V\x2d|Vbias|VbiasN
+ Vin|Vin+|Vin\x2d|Vout Vin\x2d|Vout Vbias0 Vin+|Vin\x2d|Vout Vin Vbias1 Vout
+ Vbias2$1 Vbias3$1 Vbias0$1 Vbias3$2 Vbias3$3 Vbias3$4 Vbias3$5 Vin+ Vbias0$2
+ Vbias0$3 Vbias0$4 Vbias0$5 Vbias2$2 Vbias2$3 Vbias2$4 Vbias2$5 Vbias1$1
+ Vbias1$2 Vbias1$3 Vbias1$4 Vbias1$5 V+|VbiasN Vin+|Vin\x2d|Vout$1
+ Vin\x2d|Vout$1 GND|SUB
M$1 Vbias2 VbiasP|Vo VDD VDD pfet_03v3 L=4U W=40U AS=17.6P AD=17.6P PS=80.88U
+ PD=80.88U
M$2 Vbias1 GND|SUB Vbias2 VDD pfet_03v3 L=4U W=5U AS=2.2P AD=2.2P PS=10.88U
+ PD=10.88U
M$3 \$27394 Vbias0 VDD VDD pfet_03v3 L=4U W=5U AS=2.2P AD=2.2P PS=10.88U
+ PD=10.88U
M$4 Vbias0 Vbias3 \$27394 VDD pfet_03v3 L=4U W=5U AS=2.2P AD=2.2P PS=10.88U
+ PD=10.88U
M$5 \$29441 \$31796 \$31796 \$29441 pfet_03v3 L=4U W=1U AS=0.44P AD=0.44P
+ PS=2.88U PD=2.88U
M$6 Vin+|Vin\x2d|Vout \$31796 \$31796 Vin+|Vin\x2d|Vout pfet_03v3 L=4U W=1U
+ AS=0.44P AD=0.44P PS=2.88U PD=2.88U
M$7 Vin|Vin+|Vout \$35133 \$35133 Vin|Vin+|Vout pfet_03v3 L=4U W=1U AS=0.44P
+ AD=0.44P PS=2.88U PD=2.88U
M$8 \$29442 \$35133 \$35133 \$29442 pfet_03v3 L=4U W=1U AS=0.44P AD=0.44P
+ PS=2.88U PD=2.88U
M$9 VDD VDD VDD VDD pfet_03v3 L=8U W=32U AS=14.08P AD=14.08P PS=65.76U PD=65.76U
M$10 \$40563 \$29441 \$43713 VDD pfet_03v3 L=8U W=16U AS=7.04P AD=7.04P
+ PS=32.88U PD=32.88U
M$11 \$40561 \$29441 \$43713 VDD pfet_03v3 L=8U W=144U AS=43.2P AD=43.2P
+ PS=181.4U PD=181.4U
M$15 \$40559 \$29442 \$43713 VDD pfet_03v3 L=8U W=144U AS=43.2P AD=43.2P
+ PS=181.4U PD=181.4U
M$29 \$43713 \$29442 \$40565 VDD pfet_03v3 L=8U W=16U AS=7.04P AD=7.04P
+ PS=32.88U PD=32.88U
M$31 Vbias2$1 VbiasP|Vo VDD VDD pfet_03v3 L=4U W=25U AS=11P AD=11P PS=50.88U
+ PD=50.88U
M$32 Vbias1$1 GND|SUB Vbias2$1 VDD pfet_03v3 L=4U W=5U AS=2.2P AD=2.2P
+ PS=10.88U PD=10.88U
M$33 \$60611 Vbias0$1 VDD VDD pfet_03v3 L=4U W=5U AS=2.2P AD=2.2P PS=10.88U
+ PD=10.88U
M$34 Vbias0$1 Vbias3$1 \$60611 VDD pfet_03v3 L=4U W=5U AS=2.2P AD=2.2P
+ PS=10.88U PD=10.88U
M$35 \$43713 Vbias0 VDD VDD pfet_03v3 L=4U W=10U AS=3.5P AD=3.5P PS=16.4U
+ PD=16.4U
M$37 VDD \$40566 \$43714 VDD pfet_03v3 L=8U W=10U AS=4.4P AD=4.4P PS=20.88U
+ PD=20.88U
M$38 \$40566 Vbias3 \$43714 VDD pfet_03v3 L=8U W=10U AS=4.4P AD=4.4P PS=20.88U
+ PD=20.88U
M$39 \$43715 \$40566 VDD VDD pfet_03v3 L=8U W=10U AS=4.4P AD=4.4P PS=20.88U
+ PD=20.88U
M$40 \$43715 Vbias3 Vin|Vin+|Vout VDD pfet_03v3 L=8U W=10U AS=4.4P AD=4.4P
+ PS=20.88U PD=20.88U
M$41 Vbias1$2 GND|SUB Vbias2$2 VDD pfet_03v3 L=4U W=5U AS=2.2P AD=2.2P
+ PS=10.88U PD=10.88U
M$42 \$63716 Vbias0$2 VDD VDD pfet_03v3 L=4U W=5U AS=2.2P AD=2.2P PS=10.88U
+ PD=10.88U
M$43 Vbias0$2 Vbias3$2 \$63716 VDD pfet_03v3 L=4U W=5U AS=2.2P AD=2.2P
+ PS=10.88U PD=10.88U
M$44 Vbias1$3 GND|SUB Vbias2$3 VDD pfet_03v3 L=4U W=5U AS=2.2P AD=2.2P
+ PS=10.88U PD=10.88U
M$45 \$63717 Vbias0$3 VDD VDD pfet_03v3 L=4U W=5U AS=2.2P AD=2.2P PS=10.88U
+ PD=10.88U
M$46 Vbias0$3 Vbias3$3 \$63717 VDD pfet_03v3 L=4U W=5U AS=2.2P AD=2.2P
+ PS=10.88U PD=10.88U
M$47 Vbias1$4 GND|SUB Vbias2$4 VDD pfet_03v3 L=4U W=5U AS=2.2P AD=2.2P
+ PS=10.88U PD=10.88U
M$48 \$63718 Vbias0$4 VDD VDD pfet_03v3 L=4U W=5U AS=2.2P AD=2.2P PS=10.88U
+ PD=10.88U
M$49 Vbias0$4 Vbias3$4 \$63718 VDD pfet_03v3 L=4U W=5U AS=2.2P AD=2.2P
+ PS=10.88U PD=10.88U
M$50 VDD VDD VDD VDD pfet_03v3 L=1U W=72U AS=31.68P AD=31.68P PS=175.68U
+ PD=175.68U
M$51 \$64619 Vin+ \$62657 VDD pfet_03v3 L=1U W=2U AS=0.88P AD=0.88P PS=4.88U
+ PD=4.88U
M$52 \$62330 Vin+ \$64619 VDD pfet_03v3 L=1U W=18U AS=5.76P AD=5.76P PS=29.76U
+ PD=29.76U
M$56 \$62658 Vin+|Vin\x2d|Vout \$64619 VDD pfet_03v3 L=1U W=18U AS=5.76P
+ AD=5.76P PS=29.76U PD=29.76U
M$60 \$62155 Vin+|Vin\x2d|Vout \$64619 VDD pfet_03v3 L=1U W=2U AS=0.88P
+ AD=0.88P PS=4.88U PD=4.88U
M$62 Vbias2$2 VbiasP|Vo VDD VDD pfet_03v3 L=4U W=1.25U AS=0.55P AD=0.55P
+ PS=3.38U PD=3.38U
M$63 Vbias2$3 VbiasP|Vo VDD VDD pfet_03v3 L=4U W=1.25U AS=0.55P AD=0.55P
+ PS=3.38U PD=3.38U
M$64 Vbias2$4 VbiasP|Vo VDD VDD pfet_03v3 L=4U W=2U AS=0.88P AD=0.88P PS=4.88U
+ PD=4.88U
M$65 Vbias2$5 VbiasP|Vo VDD VDD pfet_03v3 L=4U W=2U AS=0.88P AD=0.88P PS=4.88U
+ PD=4.88U
M$66 Vbias1$5 GND|SUB Vbias2$5 VDD pfet_03v3 L=4U W=5U AS=2.2P AD=2.2P
+ PS=10.88U PD=10.88U
M$67 \$63814 Vbias0$5 VDD VDD pfet_03v3 L=4U W=5U AS=2.2P AD=2.2P PS=10.88U
+ PD=10.88U
M$68 Vbias0$5 Vbias3$5 \$63814 VDD pfet_03v3 L=4U W=5U AS=2.2P AD=2.2P
+ PS=10.88U PD=10.88U
M$81 \$64619 Vbias0$1 VDD VDD pfet_03v3 L=4U W=10U AS=3.5P AD=3.5P PS=16.4U
+ PD=16.4U
M$83 VDD VDD VDD VDD pfet_03v3 L=4U W=105U AS=46.2P AD=46.2P PS=245.2U PD=245.2U
M$85 \$64288 Vbias3$1 \$65739 VDD pfet_03v3 L=4U W=5U AS=2.2P AD=2.2P PS=11.76U
+ PD=11.76U
M$86 VDD \$64288 \$65739 VDD pfet_03v3 L=4U W=5U AS=2.2P AD=2.2P PS=11.76U
+ PD=11.76U
M$87 \$65740 Vbias3$1 Vin+|Vin\x2d|Vout VDD pfet_03v3 L=4U W=5U AS=1.75P
+ AD=1.75P PS=8.9U PD=8.9U
M$89 \$65740 \$64288 VDD VDD pfet_03v3 L=4U W=5U AS=1.75P AD=1.75P PS=8.9U
+ PD=8.9U
M$96 \$68237 Vin+|Vin\x2d|Vout$1 \$66017 VDD pfet_03v3 L=1U W=2U AS=0.88P
+ AD=0.88P PS=4.88U PD=4.88U
M$97 \$66019 Vin+|Vin\x2d|Vout$1 \$68237 VDD pfet_03v3 L=1U W=18U AS=5.76P
+ AD=5.76P PS=29.76U PD=29.76U
M$101 \$66096 Vin+|Vin\x2d|Vout \$68237 VDD pfet_03v3 L=1U W=18U AS=5.76P
+ AD=5.76P PS=29.76U PD=29.76U
M$105 \$65742 Vin+|Vin\x2d|Vout \$68237 VDD pfet_03v3 L=1U W=2U AS=0.88P
+ AD=0.88P PS=4.88U PD=4.88U
M$108 \$68238 Vin+|Vin\x2d|Vout \$66021 VDD pfet_03v3 L=1U W=2U AS=0.88P
+ AD=0.88P PS=4.88U PD=4.88U
M$109 \$66022 Vin+|Vin\x2d|Vout \$68238 VDD pfet_03v3 L=1U W=18U AS=5.76P
+ AD=5.76P PS=29.76U PD=29.76U
M$113 \$66722 Vin|Vin+|Vin\x2d|Vout \$68238 VDD pfet_03v3 L=1U W=18U AS=5.76P
+ AD=5.76P PS=29.76U PD=29.76U
M$117 \$65746 Vin|Vin+|Vin\x2d|Vout \$68238 VDD pfet_03v3 L=1U W=2U AS=0.88P
+ AD=0.88P PS=4.88U PD=4.88U
M$120 \$68239 Vin|Vin+|Vin\x2d|Vout \$66025 VDD pfet_03v3 L=1U W=2U AS=0.88P
+ AD=0.88P PS=4.88U PD=4.88U
M$121 \$66026 Vin|Vin+|Vin\x2d|Vout \$68239 VDD pfet_03v3 L=1U W=18U AS=5.76P
+ AD=5.76P PS=29.76U PD=29.76U
M$125 \$66098 Vin+|Vin\x2d|Vout \$68239 VDD pfet_03v3 L=1U W=18U AS=5.76P
+ AD=5.76P PS=29.76U PD=29.76U
M$129 \$65748 Vin+|Vin\x2d|Vout \$68239 VDD pfet_03v3 L=1U W=2U AS=0.88P
+ AD=0.88P PS=4.88U PD=4.88U
M$132 \$68240 Vin+|Vin\x2d|Vout \$66029 VDD pfet_03v3 L=1U W=2U AS=0.88P
+ AD=0.88P PS=4.88U PD=4.88U
M$133 \$66030 Vin+|Vin\x2d|Vout \$68240 VDD pfet_03v3 L=1U W=18U AS=5.76P
+ AD=5.76P PS=29.76U PD=29.76U
M$137 \$66099 Vin\x2d|Vout \$68240 VDD pfet_03v3 L=1U W=18U AS=5.76P AD=5.76P
+ PS=29.76U PD=29.76U
M$141 \$65751 Vin\x2d|Vout \$68240 VDD pfet_03v3 L=1U W=2U AS=0.88P AD=0.88P
+ PS=4.88U PD=4.88U
M$191 \$68237 Vbias0$2 VDD VDD pfet_03v3 L=4U W=10U AS=3.5P AD=3.5P PS=16.4U
+ PD=16.4U
M$195 \$67726 Vbias3$2 \$69883 VDD pfet_03v3 L=4U W=5U AS=2.2P AD=2.2P
+ PS=11.76U PD=11.76U
M$196 VDD \$67726 \$69883 VDD pfet_03v3 L=4U W=5U AS=2.2P AD=2.2P PS=11.76U
+ PD=11.76U
M$197 \$69884 Vbias3$2 Vin|Vin+|Vin\x2d|Vout VDD pfet_03v3 L=4U W=5U AS=1.75P
+ AD=1.75P PS=8.9U PD=8.9U
M$199 \$69884 \$67726 VDD VDD pfet_03v3 L=4U W=5U AS=1.75P AD=1.75P PS=8.9U
+ PD=8.9U
M$205 \$68238 Vbias0$3 VDD VDD pfet_03v3 L=4U W=10U AS=3.5P AD=3.5P PS=16.4U
+ PD=16.4U
M$209 \$67728 Vbias3$3 \$69885 VDD pfet_03v3 L=4U W=5U AS=2.2P AD=2.2P
+ PS=11.76U PD=11.76U
M$210 VDD \$67728 \$69885 VDD pfet_03v3 L=4U W=5U AS=2.2P AD=2.2P PS=11.76U
+ PD=11.76U
M$211 \$69886 Vbias3$3 Vin|Vin+|Vin\x2d|Vout VDD pfet_03v3 L=4U W=5U AS=1.75P
+ AD=1.75P PS=8.9U PD=8.9U
M$213 \$69886 \$67728 VDD VDD pfet_03v3 L=4U W=5U AS=1.75P AD=1.75P PS=8.9U
+ PD=8.9U
M$219 \$68239 Vbias0$4 VDD VDD pfet_03v3 L=4U W=10U AS=3.5P AD=3.5P PS=16.4U
+ PD=16.4U
M$223 VDD \$67729 \$69887 VDD pfet_03v3 L=4U W=5U AS=2.2P AD=2.2P PS=11.76U
+ PD=11.76U
M$224 \$67729 Vbias3$4 \$69887 VDD pfet_03v3 L=4U W=5U AS=2.2P AD=2.2P
+ PS=11.76U PD=11.76U
M$225 \$69888 Vbias3$4 Vin\x2d|Vout VDD pfet_03v3 L=4U W=5U AS=1.75P AD=1.75P
+ PS=8.9U PD=8.9U
M$227 \$69888 \$67729 VDD VDD pfet_03v3 L=4U W=5U AS=1.75P AD=1.75P PS=8.9U
+ PD=8.9U
M$233 \$68240 Vbias0$5 VDD VDD pfet_03v3 L=4U W=10U AS=3.5P AD=3.5P PS=16.4U
+ PD=16.4U
M$237 \$67730 Vbias3$5 \$69889 VDD pfet_03v3 L=4U W=5U AS=2.2P AD=2.2P
+ PS=11.76U PD=11.76U
M$238 VDD \$67730 \$69889 VDD pfet_03v3 L=4U W=5U AS=2.2P AD=2.2P PS=11.76U
+ PD=11.76U
M$239 \$69890 \$67730 VDD VDD pfet_03v3 L=4U W=5U AS=1.75P AD=1.75P PS=8.9U
+ PD=8.9U
M$241 \$69890 Vbias3$5 Vin|Vin+|Vin\x2d|Vout VDD pfet_03v3 L=4U W=5U AS=1.75P
+ AD=1.75P PS=8.9U PD=8.9U
M$248 VDD \$73321 \$73321 VDD pfet_03v3 L=4U W=13U AS=5.72P AD=5.72P PS=27.76U
+ PD=27.76U
M$249 VbiasP|Vo \$73321 VDD VDD pfet_03v3 L=4U W=13U AS=4.55P AD=4.55P PS=20.9U
+ PD=20.9U
M$254 \$74816 Vin|Vin+|Vout \$72682 VDD pfet_03v3 L=1U W=2U AS=0.88P AD=0.88P
+ PS=4.88U PD=4.88U
M$255 \$72534 Vin|Vin+|Vout \$74816 VDD pfet_03v3 L=1U W=18U AS=5.76P AD=5.76P
+ PS=29.76U PD=29.76U
M$259 \$73006 Vin+|Vin\x2d|Vout \$74816 VDD pfet_03v3 L=1U W=18U AS=5.76P
+ AD=5.76P PS=29.76U PD=29.76U
M$263 \$72405 Vin+|Vin\x2d|Vout \$74816 VDD pfet_03v3 L=1U W=2U AS=0.88P
+ AD=0.88P PS=4.88U PD=4.88U
M$266 \$74817 Vin+|Vin\x2d|Vout \$72684 VDD pfet_03v3 L=1U W=2U AS=0.88P
+ AD=0.88P PS=4.88U PD=4.88U
M$267 \$72537 Vin+|Vin\x2d|Vout \$74817 VDD pfet_03v3 L=1U W=18U AS=5.76P
+ AD=5.76P PS=29.76U PD=29.76U
M$271 \$73007 Vin+|Vin\x2d|Vout$1 \$74817 VDD pfet_03v3 L=1U W=18U AS=5.76P
+ AD=5.76P PS=29.76U PD=29.76U
M$275 \$72407 Vin+|Vin\x2d|Vout$1 \$74817 VDD pfet_03v3 L=1U W=2U AS=0.88P
+ AD=0.88P PS=4.88U PD=4.88U
M$278 \$74818 Vin+|Vin\x2d|Vout$1 \$72685 VDD pfet_03v3 L=1U W=2U AS=0.88P
+ AD=0.88P PS=4.88U PD=4.88U
M$279 \$72540 Vin+|Vin\x2d|Vout$1 \$74818 VDD pfet_03v3 L=1U W=18U AS=5.76P
+ AD=5.76P PS=29.76U PD=29.76U
M$283 \$73008 Vin+|Vin\x2d|Vout \$74818 VDD pfet_03v3 L=1U W=18U AS=5.76P
+ AD=5.76P PS=29.76U PD=29.76U
M$287 \$72410 Vin+|Vin\x2d|Vout \$74818 VDD pfet_03v3 L=1U W=2U AS=0.88P
+ AD=0.88P PS=4.88U PD=4.88U
M$290 \$74819 Vin+|Vin\x2d|Vout \$72686 VDD pfet_03v3 L=1U W=2U AS=0.88P
+ AD=0.88P PS=4.88U PD=4.88U
M$291 \$72544 Vin+|Vin\x2d|Vout \$74819 VDD pfet_03v3 L=1U W=18U AS=5.76P
+ AD=5.76P PS=29.76U PD=29.76U
M$295 \$73009 Vin\x2d|Vout$1 \$74819 VDD pfet_03v3 L=1U W=18U AS=5.76P AD=5.76P
+ PS=29.76U PD=29.76U
M$299 \$72412 Vin\x2d|Vout$1 \$74819 VDD pfet_03v3 L=1U W=2U AS=0.88P AD=0.88P
+ PS=4.88U PD=4.88U
M$314 \$74507 Vbias3$2 \$76327 VDD pfet_03v3 L=4U W=5U AS=2.2P AD=2.2P
+ PS=11.76U PD=11.76U
M$315 \$76328 Vbias3$2 Vin+|Vin\x2d|Vout$1 VDD pfet_03v3 L=4U W=5U AS=1.75P
+ AD=1.75P PS=8.9U PD=8.9U
M$332 \$74508 Vbias3$3 \$76329 VDD pfet_03v3 L=4U W=5U AS=2.2P AD=2.2P
+ PS=11.76U PD=11.76U
M$333 \$76330 Vbias3$3 Vin+|Vin\x2d|Vout$1 VDD pfet_03v3 L=4U W=5U AS=1.75P
+ AD=1.75P PS=8.9U PD=8.9U
M$350 \$74509 Vbias3$4 \$76331 VDD pfet_03v3 L=4U W=5U AS=2.2P AD=2.2P
+ PS=11.76U PD=11.76U
M$351 \$76332 Vbias3$4 Vin\x2d|Vout$1 VDD pfet_03v3 L=4U W=5U AS=1.75P AD=1.75P
+ PS=8.9U PD=8.9U
M$368 \$74510 Vbias3$5 \$76333 VDD pfet_03v3 L=4U W=5U AS=2.2P AD=2.2P
+ PS=11.76U PD=11.76U
M$369 \$76334 Vbias3$5 Vin+|Vin\x2d|Vout$1 VDD pfet_03v3 L=4U W=5U AS=1.75P
+ AD=1.75P PS=8.9U PD=8.9U
M$373 \$76159 \$76159 \$74897 VDD pfet_03v3 L=40U W=0.5U AS=0.22P AD=0.22P
+ PS=1.88U PD=1.88U
M$374 \$76159 \$76159 \$76503 VDD pfet_03v3 L=40U W=0.5U AS=0.22P AD=0.22P
+ PS=1.88U PD=1.88U
M$375 VDD \$76503 \$76503 VDD pfet_03v3 L=40U W=0.5U AS=0.22P AD=0.22P PS=1.88U
+ PD=1.88U
M$377 VDD VbiasP|Vo V\x2d|Vbias|VbiasN VDD pfet_03v3 L=4U W=2U AS=0.88P
+ AD=0.88P PS=5.76U PD=5.76U
M$378 V+|VbiasN VbiasP|Vo VDD VDD pfet_03v3 L=4U W=2U AS=0.7P AD=0.7P PS=4.4U
+ PD=4.4U
M$382 \$74816 Vbias0$2 VDD VDD pfet_03v3 L=4U W=10U AS=3.5P AD=3.5P PS=16.4U
+ PD=16.4U
M$385 VDD \$74507 \$76327 VDD pfet_03v3 L=4U W=5U AS=2.2P AD=2.2P PS=11.76U
+ PD=11.76U
M$386 \$76328 \$74507 VDD VDD pfet_03v3 L=4U W=5U AS=1.75P AD=1.75P PS=8.9U
+ PD=8.9U
M$390 \$74817 Vbias0$3 VDD VDD pfet_03v3 L=4U W=10U AS=3.5P AD=3.5P PS=16.4U
+ PD=16.4U
M$393 VDD \$74508 \$76329 VDD pfet_03v3 L=4U W=5U AS=2.2P AD=2.2P PS=11.76U
+ PD=11.76U
M$394 \$76330 \$74508 VDD VDD pfet_03v3 L=4U W=5U AS=1.75P AD=1.75P PS=8.9U
+ PD=8.9U
M$398 \$74818 Vbias0$4 VDD VDD pfet_03v3 L=4U W=10U AS=3.5P AD=3.5P PS=16.4U
+ PD=16.4U
M$401 VDD \$74509 \$76331 VDD pfet_03v3 L=4U W=5U AS=2.2P AD=2.2P PS=11.76U
+ PD=11.76U
M$402 \$76332 \$74509 VDD VDD pfet_03v3 L=4U W=5U AS=1.75P AD=1.75P PS=8.9U
+ PD=8.9U
M$406 \$74819 Vbias0$5 VDD VDD pfet_03v3 L=4U W=10U AS=3.5P AD=3.5P PS=16.4U
+ PD=16.4U
M$409 VDD \$74510 \$76333 VDD pfet_03v3 L=4U W=5U AS=2.2P AD=2.2P PS=11.76U
+ PD=11.76U
M$410 \$76334 \$74510 VDD VDD pfet_03v3 L=4U W=5U AS=1.75P AD=1.75P PS=8.9U
+ PD=8.9U
M$414 VDD \$79158 \$79158 VDD pfet_03v3 L=5U W=1U AS=0.44P AD=0.44P PS=2.88U
+ PD=2.88U
M$415 \$79159 \$79159 \$79158 \$79158 pfet_03v3 L=5U W=1U AS=0.44P AD=0.44P
+ PS=2.88U PD=2.88U
M$416 \$79159 \$79161 \$79161 \$79159 pfet_03v3 L=5U W=1U AS=0.44P AD=0.44P
+ PS=2.88U PD=2.88U
M$417 \$77881 \$77881 \$79161 \$79161 pfet_03v3 L=5U W=1U AS=0.44P AD=0.44P
+ PS=2.88U PD=2.88U
M$418 GND|SUB V\x2d|Vbias|VbiasN Vbias3 GND|SUB nfet_03v3 L=4U W=80U AS=35.2P
+ AD=35.2P PS=160.88U PD=160.88U
M$419 Vbias0 VDD Vbias3 GND|SUB nfet_03v3 L=4U W=10U AS=4.4P AD=4.4P PS=20.88U
+ PD=20.88U
M$420 \$26354 Vbias1 GND|SUB GND|SUB nfet_03v3 L=4U W=1U AS=0.44P AD=0.44P
+ PS=2.88U PD=2.88U
M$421 Vbias1 Vbias2 \$26354 GND|SUB nfet_03v3 L=4U W=1U AS=0.44P AD=0.44P
+ PS=2.88U PD=2.88U
M$422 GND|SUB Vbias1 \$40559 GND|SUB nfet_03v3 L=8U W=20U AS=5.92P AD=5.92P
+ PS=29.92U PD=29.92U
M$427 \$40561 Vbias1 GND|SUB GND|SUB nfet_03v3 L=8U W=20U AS=5.92P AD=5.92P
+ PS=29.92U PD=29.92U
M$442 GND|SUB \$40563 \$40562 GND|SUB nfet_03v3 L=8U W=2U AS=0.88P AD=0.88P
+ PS=4.88U PD=4.88U
M$443 \$40563 Vbias2 \$40562 GND|SUB nfet_03v3 L=2U W=4U AS=1.76P AD=1.76P
+ PS=8.88U PD=8.88U
M$444 \$40564 Vbias2 \$40565 GND|SUB nfet_03v3 L=2U W=4U AS=1.76P AD=1.76P
+ PS=8.88U PD=8.88U
M$445 \$40564 \$40565 GND|SUB GND|SUB nfet_03v3 L=8U W=2U AS=0.88P AD=0.88P
+ PS=4.88U PD=4.88U
M$446 \$40566 Vbias2 \$40561 GND|SUB nfet_03v3 L=8U W=2U AS=0.88P AD=0.88P
+ PS=4.88U PD=4.88U
M$447 \$40559 Vbias2 Vin|Vin+|Vout GND|SUB nfet_03v3 L=8U W=2U AS=0.88P
+ AD=0.88P PS=4.88U PD=4.88U
M$448 GND|SUB V\x2d|Vbias|VbiasN Vbias3$1 GND|SUB nfet_03v3 L=4U W=50U AS=22P
+ AD=22P PS=100.88U PD=100.88U
M$449 \$58258 Vbias1$1 GND|SUB GND|SUB nfet_03v3 L=4U W=1U AS=0.44P AD=0.44P
+ PS=2.88U PD=2.88U
M$450 Vbias1$1 Vbias2$1 \$58258 GND|SUB nfet_03v3 L=4U W=1U AS=0.44P AD=0.44P
+ PS=2.88U PD=2.88U
M$451 Vbias0$1 VDD Vbias3$1 GND|SUB nfet_03v3 L=4U W=10U AS=4.4P AD=4.4P
+ PS=20.88U PD=20.88U
M$452 GND|SUB \$40563 \$40559 GND|SUB nfet_03v3 L=8U W=2U AS=0.88P AD=0.88P
+ PS=4.88U PD=4.88U
M$453 \$40561 \$40565 GND|SUB GND|SUB nfet_03v3 L=8U W=2U AS=0.88P AD=0.88P
+ PS=4.88U PD=4.88U
M$454 GND|SUB V\x2d|Vbias|VbiasN Vbias3$2 GND|SUB nfet_03v3 L=4U W=2.5U AS=1.1P
+ AD=1.1P PS=5.88U PD=5.88U
M$455 Vbias0$2 VDD Vbias3$2 GND|SUB nfet_03v3 L=4U W=10U AS=4.4P AD=4.4P
+ PS=20.88U PD=20.88U
M$456 GND|SUB V\x2d|Vbias|VbiasN Vbias3$3 GND|SUB nfet_03v3 L=4U W=2.5U AS=1.1P
+ AD=1.1P PS=5.88U PD=5.88U
M$457 Vbias0$3 VDD Vbias3$3 GND|SUB nfet_03v3 L=4U W=10U AS=4.4P AD=4.4P
+ PS=20.88U PD=20.88U
M$458 GND|SUB V\x2d|Vbias|VbiasN Vbias3$4 GND|SUB nfet_03v3 L=4U W=4U AS=1.76P
+ AD=1.76P PS=8.88U PD=8.88U
M$459 Vbias0$4 VDD Vbias3$4 GND|SUB nfet_03v3 L=4U W=10U AS=4.4P AD=4.4P
+ PS=20.88U PD=20.88U
M$460 GND|SUB GND|SUB GND|SUB GND|SUB nfet_03v3 L=4U W=84.1U AS=37.004P
+ AD=37.004P PS=250.92U PD=250.92U
M$461 GND|SUB \$62155 \$62330 GND|SUB nfet_03v3 L=4U W=1U AS=0.44P AD=0.44P
+ PS=3.76U PD=3.76U
M$462 \$62154 \$62155 GND|SUB GND|SUB nfet_03v3 L=4U W=1U AS=0.35P AD=0.35P
+ PS=2.9U PD=2.9U
M$466 GND|SUB V\x2d|Vbias|VbiasN Vbias3$5 GND|SUB nfet_03v3 L=4U W=4U AS=1.76P
+ AD=1.76P PS=8.88U PD=8.88U
M$467 Vbias0$5 VDD Vbias3$5 GND|SUB nfet_03v3 L=4U W=10U AS=4.4P AD=4.4P
+ PS=20.88U PD=20.88U
M$468 GND|SUB GND|SUB GND|SUB GND|SUB nfet_03v3 L=1U W=18U AS=7.92P AD=7.92P
+ PS=51.84U PD=51.84U
M$469 \$62155 Vbias2$1 \$62154 GND|SUB nfet_03v3 L=1U W=2U AS=0.88P AD=0.88P
+ PS=5.76U PD=5.76U
M$470 \$62657 Vbias2$1 \$62329 GND|SUB nfet_03v3 L=1U W=2U AS=0.7P AD=0.7P
+ PS=4.4U PD=4.4U
M$475 GND|SUB \$62657 \$62329 GND|SUB nfet_03v3 L=4U W=1U AS=0.44P AD=0.44P
+ PS=3.76U PD=3.76U
M$476 \$62658 \$62657 GND|SUB GND|SUB nfet_03v3 L=4U W=1U AS=0.35P AD=0.35P
+ PS=2.9U PD=2.9U
M$480 \$63003 Vbias1$2 GND|SUB GND|SUB nfet_03v3 L=4U W=1U AS=0.44P AD=0.44P
+ PS=2.88U PD=2.88U
M$481 Vbias1$2 Vbias2$2 \$63003 GND|SUB nfet_03v3 L=4U W=1U AS=0.44P AD=0.44P
+ PS=2.88U PD=2.88U
M$482 \$63007 Vbias1$3 GND|SUB GND|SUB nfet_03v3 L=4U W=1U AS=0.44P AD=0.44P
+ PS=2.88U PD=2.88U
M$483 Vbias1$3 Vbias2$3 \$63007 GND|SUB nfet_03v3 L=4U W=1U AS=0.44P AD=0.44P
+ PS=2.88U PD=2.88U
M$484 \$63011 Vbias1$4 GND|SUB GND|SUB nfet_03v3 L=4U W=1U AS=0.44P AD=0.44P
+ PS=2.88U PD=2.88U
M$485 Vbias1$4 Vbias2$4 \$63011 GND|SUB nfet_03v3 L=4U W=1U AS=0.44P AD=0.44P
+ PS=2.88U PD=2.88U
M$487 GND|SUB Vbias1$1 \$62658 GND|SUB nfet_03v3 L=4U W=10U AS=2.96P AD=2.96P
+ PS=17.92U PD=17.92U
M$492 \$62330 Vbias1$1 GND|SUB GND|SUB nfet_03v3 L=4U W=10U AS=2.96P AD=2.96P
+ PS=17.92U PD=17.92U
M$498 \$63013 Vbias1$5 GND|SUB GND|SUB nfet_03v3 L=4U W=1U AS=0.44P AD=0.44P
+ PS=2.88U PD=2.88U
M$499 Vbias1$5 Vbias2$5 \$63013 GND|SUB nfet_03v3 L=4U W=1U AS=0.44P AD=0.44P
+ PS=2.88U PD=2.88U
M$513 \$64288 Vbias2$1 \$62330 GND|SUB nfet_03v3 L=4U W=1U AS=0.44P AD=0.44P
+ PS=3.76U PD=3.76U
M$514 Vin+|Vin\x2d|Vout Vbias2$1 \$62658 GND|SUB nfet_03v3 L=4U W=1U AS=0.35P
+ AD=0.35P PS=2.9U PD=2.9U
M$519 GND|SUB \$65742 \$66019 GND|SUB nfet_03v3 L=4U W=1U AS=0.44P AD=0.44P
+ PS=3.76U PD=3.76U
M$520 \$65741 \$65742 GND|SUB GND|SUB nfet_03v3 L=4U W=1U AS=0.35P AD=0.35P
+ PS=2.9U PD=2.9U
M$525 GND|SUB \$65746 \$66022 GND|SUB nfet_03v3 L=4U W=1U AS=0.44P AD=0.44P
+ PS=3.76U PD=3.76U
M$526 \$65745 \$65746 GND|SUB GND|SUB nfet_03v3 L=4U W=1U AS=0.35P AD=0.35P
+ PS=2.9U PD=2.9U
M$531 GND|SUB \$65748 \$66026 GND|SUB nfet_03v3 L=4U W=1U AS=0.44P AD=0.44P
+ PS=3.76U PD=3.76U
M$532 \$66023 \$65748 GND|SUB GND|SUB nfet_03v3 L=4U W=1U AS=0.35P AD=0.35P
+ PS=2.9U PD=2.9U
M$537 GND|SUB \$65751 \$66030 GND|SUB nfet_03v3 L=4U W=1U AS=0.44P AD=0.44P
+ PS=3.76U PD=3.76U
M$538 \$65750 \$65751 GND|SUB GND|SUB nfet_03v3 L=4U W=1U AS=0.35P AD=0.35P
+ PS=2.9U PD=2.9U
M$543 \$65742 Vbias2$2 \$65741 GND|SUB nfet_03v3 L=1U W=2U AS=0.88P AD=0.88P
+ PS=5.76U PD=5.76U
M$544 \$66017 Vbias2$2 \$66016 GND|SUB nfet_03v3 L=1U W=2U AS=0.7P AD=0.7P
+ PS=4.4U PD=4.4U
M$549 \$65746 Vbias2$3 \$65745 GND|SUB nfet_03v3 L=1U W=2U AS=0.88P AD=0.88P
+ PS=5.76U PD=5.76U
M$550 \$66021 Vbias2$3 \$66020 GND|SUB nfet_03v3 L=1U W=2U AS=0.7P AD=0.7P
+ PS=4.4U PD=4.4U
M$555 \$65748 Vbias2$4 \$66023 GND|SUB nfet_03v3 L=1U W=2U AS=0.88P AD=0.88P
+ PS=5.76U PD=5.76U
M$556 \$66025 Vbias2$4 \$66024 GND|SUB nfet_03v3 L=1U W=2U AS=0.7P AD=0.7P
+ PS=4.4U PD=4.4U
M$561 \$65751 Vbias2$5 \$65750 GND|SUB nfet_03v3 L=1U W=2U AS=0.88P AD=0.88P
+ PS=5.76U PD=5.76U
M$562 \$66029 Vbias2$5 \$66028 GND|SUB nfet_03v3 L=1U W=2U AS=0.7P AD=0.7P
+ PS=4.4U PD=4.4U
M$567 GND|SUB Vbias1$2 \$66096 GND|SUB nfet_03v3 L=4U W=10U AS=2.96P AD=2.96P
+ PS=17.92U PD=17.92U
M$573 GND|SUB \$66017 \$66016 GND|SUB nfet_03v3 L=4U W=1U AS=0.44P AD=0.44P
+ PS=3.76U PD=3.76U
M$574 \$66096 \$66017 GND|SUB GND|SUB nfet_03v3 L=4U W=1U AS=0.35P AD=0.35P
+ PS=2.9U PD=2.9U
M$576 \$66019 Vbias1$2 GND|SUB GND|SUB nfet_03v3 L=4U W=10U AS=2.96P AD=2.96P
+ PS=17.92U PD=17.92U
M$585 GND|SUB Vbias1$3 \$66722 GND|SUB nfet_03v3 L=4U W=10U AS=2.96P AD=2.96P
+ PS=17.92U PD=17.92U
M$591 GND|SUB \$66021 \$66020 GND|SUB nfet_03v3 L=4U W=1U AS=0.44P AD=0.44P
+ PS=3.76U PD=3.76U
M$592 \$66722 \$66021 GND|SUB GND|SUB nfet_03v3 L=4U W=1U AS=0.35P AD=0.35P
+ PS=2.9U PD=2.9U
M$594 \$66022 Vbias1$3 GND|SUB GND|SUB nfet_03v3 L=4U W=10U AS=2.96P AD=2.96P
+ PS=17.92U PD=17.92U
M$603 GND|SUB Vbias1$4 \$66098 GND|SUB nfet_03v3 L=4U W=10U AS=2.96P AD=2.96P
+ PS=17.92U PD=17.92U
M$609 GND|SUB \$66025 \$66024 GND|SUB nfet_03v3 L=4U W=1U AS=0.44P AD=0.44P
+ PS=3.76U PD=3.76U
M$610 \$66098 \$66025 GND|SUB GND|SUB nfet_03v3 L=4U W=1U AS=0.35P AD=0.35P
+ PS=2.9U PD=2.9U
M$612 \$66026 Vbias1$4 GND|SUB GND|SUB nfet_03v3 L=4U W=10U AS=2.96P AD=2.96P
+ PS=17.92U PD=17.92U
M$621 GND|SUB Vbias1$5 \$66099 GND|SUB nfet_03v3 L=4U W=10U AS=2.96P AD=2.96P
+ PS=17.92U PD=17.92U
M$627 GND|SUB \$66029 \$66028 GND|SUB nfet_03v3 L=4U W=1U AS=0.44P AD=0.44P
+ PS=3.76U PD=3.76U
M$628 \$66099 \$66029 GND|SUB GND|SUB nfet_03v3 L=4U W=1U AS=0.35P AD=0.35P
+ PS=2.9U PD=2.9U
M$630 \$66030 Vbias1$5 GND|SUB GND|SUB nfet_03v3 L=4U W=10U AS=2.96P AD=2.96P
+ PS=17.92U PD=17.92U
M$687 GND|SUB \$72405 \$72534 GND|SUB nfet_03v3 L=4U W=1U AS=0.44P AD=0.44P
+ PS=3.76U PD=3.76U
M$688 \$72404 \$72405 GND|SUB GND|SUB nfet_03v3 L=4U W=1U AS=0.35P AD=0.35P
+ PS=2.9U PD=2.9U
M$691 \$67726 Vbias2$2 \$66019 GND|SUB nfet_03v3 L=4U W=1U AS=0.44P AD=0.44P
+ PS=3.76U PD=3.76U
M$693 Vin|Vin+|Vin\x2d|Vout Vbias2$2 \$66096 GND|SUB nfet_03v3 L=4U W=1U
+ AS=0.35P AD=0.35P PS=2.9U PD=2.9U
M$699 GND|SUB \$72407 \$72537 GND|SUB nfet_03v3 L=4U W=1U AS=0.44P AD=0.44P
+ PS=3.76U PD=3.76U
M$700 \$72535 \$72407 GND|SUB GND|SUB nfet_03v3 L=4U W=1U AS=0.35P AD=0.35P
+ PS=2.9U PD=2.9U
M$703 \$67728 Vbias2$3 \$66022 GND|SUB nfet_03v3 L=4U W=1U AS=0.44P AD=0.44P
+ PS=3.76U PD=3.76U
M$705 Vin|Vin+|Vin\x2d|Vout Vbias2$3 \$66722 GND|SUB nfet_03v3 L=4U W=1U
+ AS=0.35P AD=0.35P PS=2.9U PD=2.9U
M$711 GND|SUB \$72410 \$72540 GND|SUB nfet_03v3 L=4U W=1U AS=0.44P AD=0.44P
+ PS=3.76U PD=3.76U
M$712 \$72409 \$72410 GND|SUB GND|SUB nfet_03v3 L=4U W=1U AS=0.35P AD=0.35P
+ PS=2.9U PD=2.9U
M$715 \$67729 Vbias2$4 \$66026 GND|SUB nfet_03v3 L=4U W=1U AS=0.44P AD=0.44P
+ PS=3.76U PD=3.76U
M$717 Vin\x2d|Vout Vbias2$4 \$66098 GND|SUB nfet_03v3 L=4U W=1U AS=0.35P
+ AD=0.35P PS=2.9U PD=2.9U
M$723 GND|SUB \$72412 \$72544 GND|SUB nfet_03v3 L=4U W=1U AS=0.44P AD=0.44P
+ PS=3.76U PD=3.76U
M$724 \$72411 \$72412 GND|SUB GND|SUB nfet_03v3 L=4U W=1U AS=0.35P AD=0.35P
+ PS=2.9U PD=2.9U
M$727 \$67730 Vbias2$5 \$66030 GND|SUB nfet_03v3 L=4U W=1U AS=0.44P AD=0.44P
+ PS=3.76U PD=3.76U
M$729 Vin|Vin+|Vin\x2d|Vout Vbias2$5 \$66099 GND|SUB nfet_03v3 L=4U W=1U
+ AS=0.35P AD=0.35P PS=2.9U PD=2.9U
M$735 \$72405 Vbias2$2 \$72404 GND|SUB nfet_03v3 L=1U W=2U AS=0.88P AD=0.88P
+ PS=5.76U PD=5.76U
M$736 \$72682 Vbias2$2 \$72533 GND|SUB nfet_03v3 L=1U W=2U AS=0.7P AD=0.7P
+ PS=4.4U PD=4.4U
M$741 \$72407 Vbias2$3 \$72535 GND|SUB nfet_03v3 L=1U W=2U AS=0.88P AD=0.88P
+ PS=5.76U PD=5.76U
M$742 \$72684 Vbias2$3 \$72536 GND|SUB nfet_03v3 L=1U W=2U AS=0.7P AD=0.7P
+ PS=4.4U PD=4.4U
M$747 \$72410 Vbias2$4 \$72409 GND|SUB nfet_03v3 L=1U W=2U AS=0.88P AD=0.88P
+ PS=5.76U PD=5.76U
M$748 \$72685 Vbias2$4 \$72539 GND|SUB nfet_03v3 L=1U W=2U AS=0.7P AD=0.7P
+ PS=4.4U PD=4.4U
M$753 \$72412 Vbias2$5 \$72411 GND|SUB nfet_03v3 L=1U W=2U AS=0.88P AD=0.88P
+ PS=5.76U PD=5.76U
M$754 \$72686 Vbias2$5 \$72543 GND|SUB nfet_03v3 L=1U W=2U AS=0.7P AD=0.7P
+ PS=4.4U PD=4.4U
M$759 V+|VbiasN V\x2d|Vbias|VbiasN \$69872 GND|SUB nfet_03v3 L=4U W=40U AS=14P
+ AD=14P PS=62.8U PD=62.8U
M$761 GND|SUB V\x2d|Vbias|VbiasN V\x2d|Vbias|VbiasN GND|SUB nfet_03v3 L=4U
+ W=10U AS=4.4P AD=4.4P PS=20.88U PD=20.88U
M$766 \$72614 V+|VbiasN \$73321 GND|SUB nfet_03v3 L=4U W=1.1U AS=0.484P
+ AD=0.484P PS=3.96U PD=3.96U
M$767 VbiasP|Vo V\x2d|Vbias|VbiasN \$72614 GND|SUB nfet_03v3 L=4U W=1.1U
+ AS=0.385P AD=0.385P PS=3.05U PD=3.05U
M$769 GND|SUB V\x2d|Vbias|VbiasN \$72614 GND|SUB nfet_03v3 L=4U W=2.2U
+ AS=0.968P AD=0.968P PS=5.28U PD=5.28U
M$773 GND|SUB Vbias1$2 \$73006 GND|SUB nfet_03v3 L=4U W=10U AS=2.96P AD=2.96P
+ PS=17.92U PD=17.92U
M$779 GND|SUB \$72682 \$72533 GND|SUB nfet_03v3 L=4U W=1U AS=0.44P AD=0.44P
+ PS=3.76U PD=3.76U
M$780 \$73006 \$72682 GND|SUB GND|SUB nfet_03v3 L=4U W=1U AS=0.35P AD=0.35P
+ PS=2.9U PD=2.9U
M$782 \$72534 Vbias1$2 GND|SUB GND|SUB nfet_03v3 L=4U W=10U AS=2.96P AD=2.96P
+ PS=17.92U PD=17.92U
M$791 GND|SUB Vbias1$3 \$73007 GND|SUB nfet_03v3 L=4U W=10U AS=2.96P AD=2.96P
+ PS=17.92U PD=17.92U
M$797 GND|SUB \$72684 \$72536 GND|SUB nfet_03v3 L=4U W=1U AS=0.44P AD=0.44P
+ PS=3.76U PD=3.76U
M$798 \$73007 \$72684 GND|SUB GND|SUB nfet_03v3 L=4U W=1U AS=0.35P AD=0.35P
+ PS=2.9U PD=2.9U
M$800 \$72537 Vbias1$3 GND|SUB GND|SUB nfet_03v3 L=4U W=10U AS=2.96P AD=2.96P
+ PS=17.92U PD=17.92U
M$809 GND|SUB Vbias1$4 \$73008 GND|SUB nfet_03v3 L=4U W=10U AS=2.96P AD=2.96P
+ PS=17.92U PD=17.92U
M$815 GND|SUB \$72685 \$72539 GND|SUB nfet_03v3 L=4U W=1U AS=0.44P AD=0.44P
+ PS=3.76U PD=3.76U
M$816 \$73008 \$72685 GND|SUB GND|SUB nfet_03v3 L=4U W=1U AS=0.35P AD=0.35P
+ PS=2.9U PD=2.9U
M$818 \$72540 Vbias1$4 GND|SUB GND|SUB nfet_03v3 L=4U W=10U AS=2.96P AD=2.96P
+ PS=17.92U PD=17.92U
M$827 GND|SUB Vbias1$5 \$73009 GND|SUB nfet_03v3 L=4U W=10U AS=2.96P AD=2.96P
+ PS=17.92U PD=17.92U
M$833 GND|SUB \$72686 \$72543 GND|SUB nfet_03v3 L=4U W=1U AS=0.44P AD=0.44P
+ PS=3.76U PD=3.76U
M$834 \$73009 \$72686 GND|SUB GND|SUB nfet_03v3 L=4U W=1U AS=0.35P AD=0.35P
+ PS=2.9U PD=2.9U
M$836 \$72544 Vbias1$5 GND|SUB GND|SUB nfet_03v3 L=4U W=10U AS=2.96P AD=2.96P
+ PS=17.92U PD=17.92U
M$856 \$74507 Vbias2$2 \$72534 GND|SUB nfet_03v3 L=4U W=1U AS=0.44P AD=0.44P
+ PS=3.76U PD=3.76U
M$857 Vin+|Vin\x2d|Vout$1 Vbias2$2 \$73006 GND|SUB nfet_03v3 L=4U W=1U AS=0.35P
+ AD=0.35P PS=2.9U PD=2.9U
M$874 \$74508 Vbias2$3 \$72537 GND|SUB nfet_03v3 L=4U W=1U AS=0.44P AD=0.44P
+ PS=3.76U PD=3.76U
M$875 Vin+|Vin\x2d|Vout$1 Vbias2$3 \$73007 GND|SUB nfet_03v3 L=4U W=1U AS=0.35P
+ AD=0.35P PS=2.9U PD=2.9U
M$892 \$74509 Vbias2$4 \$72540 GND|SUB nfet_03v3 L=4U W=1U AS=0.44P AD=0.44P
+ PS=3.76U PD=3.76U
M$893 Vin\x2d|Vout$1 Vbias2$4 \$73008 GND|SUB nfet_03v3 L=4U W=1U AS=0.35P
+ AD=0.35P PS=2.9U PD=2.9U
M$910 \$74510 Vbias2$5 \$72544 GND|SUB nfet_03v3 L=4U W=1U AS=0.44P AD=0.44P
+ PS=3.76U PD=3.76U
M$911 Vin+|Vin\x2d|Vout$1 Vbias2$5 \$73009 GND|SUB nfet_03v3 L=4U W=1U AS=0.35P
+ AD=0.35P PS=2.9U PD=2.9U
M$916 \$74897 V\x2d|Vbias|VbiasN GND|SUB GND|SUB nfet_03v3 L=10U W=1U AS=0.44P
+ AD=0.44P PS=2.88U PD=2.88U
M$917 VbiasP|Vo \$74897 V\x2d|Vbias|VbiasN GND|SUB nfet_03v3 L=1U W=1U AS=0.44P
+ AD=0.44P PS=2.88U PD=2.88U
M$918 VDD Vin|Vin+|Vin\x2d|Vout Vout GND|SUB nfet_03v3 L=1U W=2U AS=0.88P
+ AD=0.88P PS=4.88U PD=4.88U
M$919 Vout \$77881 GND|SUB GND|SUB nfet_03v3 L=4U W=7U AS=3.08P AD=3.08P
+ PS=14.88U PD=14.88U
M$920 GND|SUB \$77881 \$77881 GND|SUB nfet_03v3 L=4U W=5U AS=1.48P AD=1.48P
+ PS=8.96U PD=8.96U
R$925 GND|SUB GND|SUB GND|SUB 3750 ppolyf_u_1k L=30U W=8U
R$955 GND|SUB Vin+ GND|SUB 300000 ppolyf_u_1k L=600U W=2U
R$967 VDD Vin+ GND|SUB 300000 ppolyf_u_1k L=600U W=2U
R$988 GND|SUB \$69872 GND|SUB 410000 ppolyf_u_1k L=820U W=2U
C$989 GND|SUB Vin|Vin+|Vout 5e-12 cap_mim_2f0fF A=2500P P=1000U
C$999 GND|SUB GND|SUB 2.88e-11 cap_mim_2f0fF A=14400P P=5760U
C$1027 GND|SUB Vin|Vin+|Vin\x2d|Vout 1.28e-11 cap_mim_2f0fF A=6400P P=2560U
C$1039 GND|SUB Vin\x2d|Vout 1.28e-11 cap_mim_2f0fF A=6400P P=2560U
C$1074 Vin+|Vin\x2d|Vout \$29441 2.2e-12 cap_mim_2f0fF A=1100P P=440U
C$1079 Vin \$29442 2e-12 cap_mim_2f0fF A=1000P P=400U
C$1110 Vin|Vin+|Vout \$29442 2e-13 cap_mim_2f0fF A=100P P=40U
C$1216 Vout GND|SUB 2e-11 cap_mim_2f0fF A=10000P P=4000U
C$1354 GND|SUB Vin+|Vin\x2d|Vout$1 1.28e-11 cap_mim_2f0fF A=6400P P=2560U
C$1366 GND|SUB Vin\x2d|Vout$1 1.28e-11 cap_mim_2f0fF A=6400P P=2560U
.ENDS B04_TOP
