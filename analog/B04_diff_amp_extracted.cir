* Extracted by KLayout with GF180MCU LVS runset on : 09/08/2026 08:18

.SUBCKT B04_diff_amp Vbias V+ V\x2d Vo VDD GND
M$1 Vo \$7 VDD VDD pfet_03v3 L=4U W=13U AS=4.55P AD=4.55P PS=20.9U PD=20.9U
M$3 VDD \$7 \$7 VDD pfet_03v3 L=4U W=13U AS=5.72P AD=5.72P PS=27.76U PD=27.76U
M$5 VDD VDD VDD VDD pfet_03v3 L=4U W=13U AS=5.72P AD=5.72P PS=27.76U PD=27.76U
M$7 Vo V\x2d \$4 GND nfet_03v3 L=4U W=1.1U AS=0.385P AD=0.385P PS=3.05U PD=3.05U
M$9 GND Vbias \$4 GND nfet_03v3 L=4U W=2.2U AS=0.968P AD=0.968P PS=5.28U
+ PD=5.28U
M$10 \$7 V+ \$4 GND nfet_03v3 L=4U W=1.1U AS=0.484P AD=0.484P PS=3.96U PD=3.96U
M$12 GND GND GND GND nfet_03v3 L=4U W=1.1U AS=0.484P AD=0.484P PS=3.96U PD=3.96U
.ENDS B04_diff_amp
