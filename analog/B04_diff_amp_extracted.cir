* Extracted by KLayout with GF180MCU LVS runset on : 01/08/2026 11:30

.SUBCKT B04_diff_amp VSS Vbias V+ V\x2d Vo VDD
M$1 VSS Vbias \$3 VSS nfet_03v3 L=4U W=2.2U AS=0.968P AD=0.968P PS=5.28U
+ PD=5.28U
M$2 \$3 V+ \$7 VSS nfet_03v3 L=4U W=1.1U AS=0.484P AD=0.484P PS=3.08U PD=3.08U
M$3 \$3 V\x2d Vo VSS nfet_03v3 L=4U W=1.1U AS=0.484P AD=0.484P PS=3.08U PD=3.08U
M$4 Vo \$7 VDD VDD pfet_03v3 L=4U W=13U AS=5.72P AD=5.72P PS=26.88U PD=26.88U
M$5 \$7 \$7 VDD VDD pfet_03v3 L=4U W=13U AS=5.72P AD=5.72P PS=26.88U PD=26.88U
.ENDS B04_diff_amp
