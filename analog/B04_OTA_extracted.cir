* Extracted by KLayout with GF180MCU LVS runset on : 11/08/2026 05:21

.SUBCKT B04_OTA Vbias2 Vbias1 VDD Vin+ Vin\x2d Vout Vbias3 Vbias0 GND
M$1 \$22 \$12 VDD VDD pfet_03v3 L=4U W=5U AS=1.75P AD=1.75P PS=8.9U PD=8.9U
M$3 VDD VDD VDD VDD pfet_03v3 L=4U W=10U AS=4.4P AD=4.4P PS=23.52U PD=23.52U
M$5 VDD \$12 \$23 VDD pfet_03v3 L=4U W=5U AS=2.2P AD=2.2P PS=11.76U PD=11.76U
M$7 \$16 Vbias0 VDD VDD pfet_03v3 L=4U W=10U AS=3.5P AD=3.5P PS=16.4U PD=16.4U
M$9 \$22 Vbias3 Vout VDD pfet_03v3 L=4U W=5U AS=1.75P AD=1.75P PS=8.9U PD=8.9U
M$13 \$12 Vbias3 \$23 VDD pfet_03v3 L=4U W=5U AS=2.2P AD=2.2P PS=11.76U
+ PD=11.76U
M$15 \$6 Vin+ \$16 VDD pfet_03v3 L=1U W=18U AS=5.76P AD=5.76P PS=29.76U
+ PD=29.76U
M$19 \$8 Vin\x2d \$16 VDD pfet_03v3 L=1U W=18U AS=5.76P AD=5.76P PS=29.76U
+ PD=29.76U
M$25 VDD VDD VDD VDD pfet_03v3 L=1U W=8U AS=3.52P AD=3.52P PS=19.52U PD=19.52U
M$35 \$3 Vin\x2d \$16 VDD pfet_03v3 L=1U W=2U AS=0.88P AD=0.88P PS=4.88U
+ PD=4.88U
M$36 \$16 Vin+ \$5 VDD pfet_03v3 L=1U W=2U AS=0.88P AD=0.88P PS=4.88U PD=4.88U
M$39 \$8 \$5 GND GND nfet_03v3 L=4U W=1U AS=0.35P AD=0.35P PS=2.9U PD=2.9U
M$41 \$2 \$3 GND GND nfet_03v3 L=4U W=1U AS=0.35P AD=0.35P PS=2.9U PD=2.9U
M$43 Vout Vbias2 \$8 GND nfet_03v3 L=4U W=1U AS=0.35P AD=0.35P PS=2.9U PD=2.9U
M$45 GND GND GND GND nfet_03v3 L=4U W=7U AS=3.08P AD=3.08P PS=22.8U PD=22.8U
M$49 GND Vbias1 \$6 GND nfet_03v3 L=4U W=10U AS=2.96P AD=2.96P PS=17.92U
+ PD=17.92U
M$59 GND Vbias1 \$8 GND nfet_03v3 L=4U W=10U AS=2.96P AD=2.96P PS=17.92U
+ PD=17.92U
M$69 \$5 Vbias2 \$4 GND nfet_03v3 L=1U W=2U AS=0.7P AD=0.7P PS=4.4U PD=4.4U
M$71 \$2 Vbias2 \$3 GND nfet_03v3 L=1U W=2U AS=0.88P AD=0.88P PS=5.76U PD=5.76U
M$73 GND GND GND GND nfet_03v3 L=1U W=2U AS=0.88P AD=0.88P PS=5.76U PD=5.76U
M$75 GND \$5 \$4 GND nfet_03v3 L=4U W=1U AS=0.44P AD=0.44P PS=3.76U PD=3.76U
M$79 \$6 \$3 GND GND nfet_03v3 L=4U W=1U AS=0.44P AD=0.44P PS=3.76U PD=3.76U
M$81 \$12 Vbias2 \$6 GND nfet_03v3 L=4U W=1U AS=0.44P AD=0.44P PS=3.76U PD=3.76U
.ENDS B04_OTA
