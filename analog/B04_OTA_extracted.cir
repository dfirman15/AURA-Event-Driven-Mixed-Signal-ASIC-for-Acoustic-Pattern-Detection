* Extracted by KLayout with GF180MCU LVS runset on : 09/08/2026 18:35

.SUBCKT B04_OTA Vbias2 Vbias1 VDD Vin+ Vin\x2d Vbias3 Vbias0 GND
M$1 \$22 \$11 VDD VDD pfet_03v3 L=4U W=5U AS=1.75P AD=1.75P PS=8.9U PD=8.9U
M$3 VDD VDD VDD VDD pfet_03v3 L=4U W=10U AS=4.4P AD=4.4P PS=23.52U PD=23.52U
M$5 VDD \$11 \$23 VDD pfet_03v3 L=4U W=5U AS=2.2P AD=2.2P PS=11.76U PD=11.76U
M$7 \$16 Vbias0 VDD VDD pfet_03v3 L=4U W=10U AS=3.5P AD=3.5P PS=16.4U PD=16.4U
M$9 \$22 Vbias3 \$15 VDD pfet_03v3 L=4U W=5U AS=1.75P AD=1.75P PS=8.9U PD=8.9U
M$13 \$11 Vbias3 \$23 VDD pfet_03v3 L=4U W=5U AS=2.2P AD=2.2P PS=11.76U
+ PD=11.76U
M$15 \$5 Vin+ \$16 VDD pfet_03v3 L=1U W=18U AS=5.76P AD=5.76P PS=29.76U
+ PD=29.76U
M$19 \$7 Vin\x2d \$16 VDD pfet_03v3 L=1U W=18U AS=5.76P AD=5.76P PS=29.76U
+ PD=29.76U
M$25 VDD VDD VDD VDD pfet_03v3 L=1U W=8U AS=3.52P AD=3.52P PS=19.52U PD=19.52U
M$35 \$16 Vin+ \$4 VDD pfet_03v3 L=1U W=2U AS=0.88P AD=0.88P PS=4.88U PD=4.88U
M$38 \$14 Vin\x2d \$16 VDD pfet_03v3 L=1U W=2U AS=0.88P AD=0.88P PS=4.88U
+ PD=4.88U
M$39 \$7 \$4 GND GND nfet_03v3 L=4U W=1U AS=0.35P AD=0.35P PS=2.9U PD=2.9U
M$41 \$2 \$14 GND GND nfet_03v3 L=4U W=1U AS=0.35P AD=0.35P PS=2.9U PD=2.9U
M$43 \$15 Vbias2 \$7 GND nfet_03v3 L=4U W=1U AS=0.35P AD=0.35P PS=2.9U PD=2.9U
M$45 GND GND GND GND nfet_03v3 L=4U W=7U AS=3.08P AD=3.08P PS=22.8U PD=22.8U
M$49 GND Vbias1 \$5 GND nfet_03v3 L=4U W=10U AS=2.96P AD=2.96P PS=17.92U
+ PD=17.92U
M$59 GND Vbias1 \$7 GND nfet_03v3 L=4U W=10U AS=2.96P AD=2.96P PS=17.92U
+ PD=17.92U
M$69 \$4 Vbias2 \$3 GND nfet_03v3 L=1U W=2U AS=0.7P AD=0.7P PS=4.4U PD=4.4U
M$71 \$2 Vbias2 \$14 GND nfet_03v3 L=1U W=2U AS=0.88P AD=0.88P PS=5.76U PD=5.76U
M$73 GND GND GND GND nfet_03v3 L=1U W=2U AS=0.88P AD=0.88P PS=5.76U PD=5.76U
M$75 GND \$4 \$3 GND nfet_03v3 L=4U W=1U AS=0.44P AD=0.44P PS=3.76U PD=3.76U
M$79 \$11 Vbias2 \$5 GND nfet_03v3 L=4U W=1U AS=0.44P AD=0.44P PS=3.76U PD=3.76U
M$80 GND \$14 \$5 GND nfet_03v3 L=4U W=1U AS=0.44P AD=0.44P PS=3.76U PD=3.76U
.ENDS B04_OTA
