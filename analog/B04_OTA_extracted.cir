* Extracted by KLayout with GF180MCU LVS runset on : 03/08/2026 18:44

.SUBCKT B04_OTA Vbias2 Vbias1 Vbias3 Vin+ Vin\x2d VDD Vbias0 GND
M$1 \$7 Vin+ \$23 VDD pfet_03v3 L=1U W=2U AS=0.88P AD=0.88P PS=4.88U PD=4.88U
M$2 \$23 Vin\x2d \$8 VDD pfet_03v3 L=1U W=2U AS=0.88P AD=0.88P PS=4.88U PD=4.88U
M$3 \$9 Vin\x2d \$23 VDD pfet_03v3 L=1U W=18U AS=5.4P AD=5.4P PS=27.4U PD=27.4U
M$7 \$10 Vin+ \$23 VDD pfet_03v3 L=1U W=18U AS=5.4P AD=5.4P PS=27.4U PD=27.4U
M$21 \$23 Vbias0 VDD VDD pfet_03v3 L=4U W=10U AS=3.5P AD=3.5P PS=16.4U PD=16.4U
M$23 \$17 Vbias3 \$21 VDD pfet_03v3 L=4U W=5U AS=2.2P AD=2.2P PS=10.88U
+ PD=10.88U
M$24 \$22 \$17 VDD VDD pfet_03v3 L=4U W=5U AS=2.2P AD=2.2P PS=10.88U PD=10.88U
M$25 VDD \$17 \$21 VDD pfet_03v3 L=4U W=5U AS=2.2P AD=2.2P PS=10.88U PD=10.88U
M$26 \$22 Vbias3 \$18 VDD pfet_03v3 L=4U W=5U AS=2.2P AD=2.2P PS=10.88U
+ PD=10.88U
M$27 \$9 Vbias1 GND GND nfet_03v3 L=4U W=10U AS=2.96P AD=2.96P PS=17.92U
+ PD=17.92U
M$37 GND Vbias1 \$10 GND nfet_03v3 L=4U W=10U AS=2.96P AD=2.96P PS=17.92U
+ PD=17.92U
M$47 \$9 Vbias2 \$18 GND nfet_03v3 L=4U W=1U AS=0.44P AD=0.44P PS=2.88U PD=2.88U
M$48 \$17 Vbias2 \$10 GND nfet_03v3 L=4U W=1U AS=0.44P AD=0.44P PS=2.88U
+ PD=2.88U
M$49 \$3 \$7 GND GND nfet_03v3 L=4U W=1U AS=0.44P AD=0.44P PS=2.88U PD=2.88U
M$50 GND \$8 \$4 GND nfet_03v3 L=4U W=1U AS=0.44P AD=0.44P PS=2.88U PD=2.88U
M$51 \$9 \$7 GND GND nfet_03v3 L=4U W=1U AS=0.44P AD=0.44P PS=2.88U PD=2.88U
M$52 GND \$8 \$10 GND nfet_03v3 L=4U W=1U AS=0.44P AD=0.44P PS=2.88U PD=2.88U
M$53 \$7 Vbias2 \$3 GND nfet_03v3 L=1U W=2U AS=0.88P AD=0.88P PS=4.88U PD=4.88U
M$54 \$4 Vbias2 \$8 GND nfet_03v3 L=1U W=2U AS=0.88P AD=0.88P PS=4.88U PD=4.88U
.ENDS B04_OTA
