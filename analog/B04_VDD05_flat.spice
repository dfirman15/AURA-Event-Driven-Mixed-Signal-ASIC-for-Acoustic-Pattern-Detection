* NGSPICE file created from B04_VDD05_flat.ext - technology: gf180mcuD

.subckt B04_VDD05_flat VDD GND VbiasN
X0 a_n3954_6382.t1 a_n4434_260.t1 GND.t59 ppolyf_u_1k r_width=2u r_length=30u
X1 a_5946_4337.t2 a_6034_5405.t4 VDD.t40 VDD.t39 pfet_03v3 ad=1.1p pd=5.88u as=1.1p ps=5.88u w=2.5u l=4u
X2 GND.t5 a_2584_2555.t9 a_2872_2555.t0 GND.t4 nfet_03v3 ad=0.22p pd=1.88u as=0.22p ps=1.88u w=0.5u l=4u
X3 VDD.t43 a_6034_5405.t7 a_5946_4337.t3 VDD.t42 pfet_03v3 ad=1.1p pd=5.88u as=1.1p ps=5.88u w=2.5u l=4u
X4 GND.t39 GND.t38 GND.t39 GND.t27 nfet_03v3 ad=0.44p pd=2.88u as=0 ps=0 w=1u l=1u
X5 a_2872_2967.t2 a_1974_4337.t8 GND.t74 GND.t64 nfet_03v3 ad=0.22p pd=1.88u as=0.22p ps=1.88u w=0.5u l=4u
X6 GND.t6 a_2584_2555.t7 a_3334_4669.t1 GND.t4 nfet_03v3 ad=0.22p pd=1.88u as=0.22p ps=1.88u w=0.5u l=4u
X7 a_1974_4669.t5 a_1974_4337.t6 GND.t65 GND.t64 nfet_03v3 ad=0.22p pd=1.88u as=0.22p ps=1.88u w=0.5u l=4u
X8 a_3334_4669.t6 B04_OTA_0.Vin-.t11 a_1686_4337.t0 VDD.t27 pfet_03v3 ad=0.13p pd=1.02u as=0.22p ps=1.88u w=0.5u l=1u
X9 VDD.t8 VDD.t6 VDD.t8 VDD.t7 pfet_03v3 ad=0.22p pd=1.88u as=0 ps=0 w=0.5u l=1u
X10 a_1686_4337.t9 B04_OTA_0.Vbias0.t4 VDD.t33 VDD.t32 pfet_03v3 ad=0.65p pd=3.02u as=1.1p ps=5.88u w=2.5u l=4u
X11 a_n6834_6382.t1 a_n6354_260.t1 GND.t0 ppolyf_u_1k r_width=2u r_length=30u
X12 a_n6834_6382.t0 a_n7314_260.t0 GND.t54 ppolyf_u_1k r_width=2u r_length=30u
X13 a_1686_4337.t7 B04_OTA_0.Vin-.t4 a_1974_4337.t2 VDD.t31 pfet_03v3 ad=0.22p pd=1.88u as=0.13p ps=1.02u w=0.5u l=1u
X14 GND.t44 GND.t42 GND.t44 GND.t43 nfet_03v3 ad=0.22p pd=1.88u as=0 ps=0 w=0.5u l=4u
X15 GND.t49 GND.t48 GND.t49 GND.t43 nfet_03v3 ad=0.22p pd=1.88u as=0 ps=0 w=0.5u l=4u
X16 a_n9714_6382.t1 a_n9234_260.t1 GND.t18 ppolyf_u_1k r_width=2u r_length=30u
X17 a_n9714_6382.t0 a_n10194_260.t1 GND.t17 ppolyf_u_1k r_width=2u r_length=30u
X18 GND.t28 GND.t26 GND.t28 GND.t27 nfet_03v3 ad=0.44p pd=2.88u as=0 ps=0 w=1u l=1u
X19 VDD.t19 VDD.t18 VDD.t19 VDD.t4 pfet_03v3 ad=1.1p pd=5.88u as=0 ps=0 w=2.5u l=4u
X20 a_1974_4337.t1 B04_OTA_0.Vbias2.t3 a_2872_2967.t3 GND.t77 nfet_03v3 ad=0.44p pd=2.88u as=0.44p ps=2.88u w=1u l=1u
X21 a_3334_4669.t0 a_2584_2555.t8 GND.t80 GND.t79 nfet_03v3 ad=0.22p pd=1.88u as=0.22p ps=1.88u w=0.5u l=4u
X22 a_1686_4337.t10 B04_OTA_0.Vin+.t8 a_1974_4669.t6 VDD.t34 pfet_03v3 ad=0.13p pd=1.02u as=0.13p ps=1.02u w=0.5u l=1u
X23 B04_OTA_0.Vbias2.t0 B04_OTA_bias_ratio_5_0.VbiasP VDD.t21 VDD.t20 pfet_03v3 ad=11p pd=50.88u as=11p ps=50.88u w=25u l=4u
X24 a_5946_4337.t1 B04_OTA_0.Vbias3.t3 B04_OTA_0.Vin-.t3 VDD.t39 pfet_03v3 ad=1.1p pd=5.88u as=1.1p ps=5.88u w=2.5u l=4u
X25 VDD.t25 B04_OTA_0.Vbias0.t3 a_1686_4337.t8 VDD.t24 pfet_03v3 ad=1.1p pd=5.88u as=0.65p ps=3.02u w=2.5u l=4u
X26 a_2872_2555.t3 a_2584_2555.t6 GND.t85 GND.t79 nfet_03v3 ad=0.22p pd=1.88u as=0.22p ps=1.88u w=0.5u l=4u
X27 B04_OTA_0.Vin-.t2 B04_OTA_0.Vbias3.t6 a_5946_4337.t0 VDD.t42 pfet_03v3 ad=1.1p pd=5.88u as=1.1p ps=5.88u w=2.5u l=4u
X28 a_n2994_6382.t0 a_n3474_260.t0 GND.t23 ppolyf_u_1k r_width=2u r_length=30u
X29 VDD.t13 VDD.t12 VDD.t13 VDD.t7 pfet_03v3 ad=0.22p pd=1.88u as=0 ps=0 w=0.5u l=1u
X30 a_2584_2555.t2 B04_OTA_0.Vin+.t5 a_1686_4337.t12 VDD.t27 pfet_03v3 ad=0.13p pd=1.02u as=0.22p ps=1.88u w=0.5u l=1u
X31 a_n5874_6382.t1 a_n5394_260.t1 GND.t56 ppolyf_u_1k r_width=2u r_length=30u
X32 a_n5874_6382.t0 a_n6354_n2.t1 GND.t7 ppolyf_u_1k r_width=2u r_length=30u
X33 GND.t37 GND.t35 GND.t37 GND.t36 nfet_03v3 ad=0.22p pd=1.88u as=0 ps=0 w=0.5u l=4u
X34 a_2584_2555.t0 B04_OTA_0.Vbias2.t9 a_2872_2555.t2 GND.t77 nfet_03v3 ad=0.44p pd=2.88u as=0.44p ps=2.88u w=1u l=1u
X35 a_1686_4337.t1 B04_OTA_0.Vin-.t10 a_3334_4669.t8 VDD.t30 pfet_03v3 ad=0.13p pd=1.02u as=0.13p ps=1.02u w=0.5u l=1u
X36 a_3334_4669.t2 B04_OTA_0.Vbias2.t5 B04_OTA_0.Vin-.t1 GND.t67 nfet_03v3 ad=0.22p pd=1.88u as=0.22p ps=1.88u w=0.5u l=4u
X37 a_n4434_n2.t1 a_n4914_n6124.t0 GND.t72 ppolyf_u_1k r_width=2u r_length=30u
X38 B04_OTA_0.Vin-.t0 B04_OTA_0.Vbias2.t8 a_3334_4669.t3 GND.t78 nfet_03v3 ad=0.22p pd=1.88u as=0.22p ps=1.88u w=0.5u l=4u
X39 a_1686_4337.t5 B04_OTA_0.Vin-.t6 a_1974_4337.t3 VDD.t34 pfet_03v3 ad=0.13p pd=1.02u as=0.13p ps=1.02u w=0.5u l=1u
X40 a_3430_n2670.t0 B04_OTA_0.Vbias1.t2 GND.t63 GND.t62 nfet_03v3 ad=0.44p pd=2.88u as=0.44p ps=2.88u w=1u l=4u
X41 a_n5394_n2.t0 a_n4914_n6124.t1 GND.t55 ppolyf_u_1k r_width=2u r_length=30u
X42 a_n8754_6382.t1 a_n8274_260.t0 GND.t53 ppolyf_u_1k r_width=2u r_length=30u
X43 GND.t24 GND.t25 GND.t19 ppolyf_u_1k r_width=2u r_length=30u
X44 a_n8754_6382.t0 a_n9234_260.t0 GND.t52 ppolyf_u_1k r_width=2u r_length=30u
X45 a_n3474_n2.t0 a_n3954_n6124.t0 GND.t57 ppolyf_u_1k r_width=2u r_length=30u
X46 a_6630_n1720.t1 B04_OTA_0.Vbias0.t2 VDD.t38 VDD.t37 pfet_03v3 ad=2.2p pd=10.88u as=2.2p ps=10.88u w=5u l=4u
X47 a_n9234_n2.t0 a_n9714_n6124.t0 GND.t18 ppolyf_u_1k r_width=2u r_length=30u
X48 a_1686_4337.t3 B04_OTA_0.Vin-.t8 a_3334_4669.t9 VDD.t45 pfet_03v3 ad=0.22p pd=1.88u as=0.13p ps=1.02u w=0.5u l=1u
X49 a_n4434_n2.t0 a_n3954_n6124.t1 GND.t59 ppolyf_u_1k r_width=2u r_length=30u
X50 GND.t2 VbiasN.t0 B04_OTA_0.Vbias3.t0 GND.t1 nfet_03v3 ad=22p pd=0.10088m as=22p ps=0.10088m w=50u l=4u
X51 a_n10194_n2.t0 a_n10674_n6124.t1 GND.t16 ppolyf_u_1k r_width=2u r_length=30u
X52 a_6996_4337.t2 a_6034_5405.t6 VDD.t41 VDD.t26 pfet_03v3 ad=1.1p pd=5.88u as=1.1p ps=5.88u w=2.5u l=4u
X53 a_n10194_n2.t1 a_n9714_n6124.t1 GND.t17 ppolyf_u_1k r_width=2u r_length=30u
X54 a_n2034_6382.t0 a_n2514_260.t1 GND.t61 ppolyf_u_1k r_width=2u r_length=30u
X55 GND.t84 B04_OTA_0.Vbias1.t6 a_1974_4669.t2 GND.t10 nfet_03v3 ad=0.22p pd=1.88u as=0.22p ps=1.88u w=0.5u l=4u
X56 VDD.t11 VDD.t9 VDD.t11 VDD.t10 pfet_03v3 ad=0.22p pd=1.88u as=0 ps=0 w=0.5u l=1u
X57 a_n8274_n2.t0 a_n8754_n6124.t1 GND.t53 ppolyf_u_1k r_width=2u r_length=30u
X58 B04_OTA_0.Vin+.t1 a_n10674_n6124.t0 GND.t22 ppolyf_u_1k r_width=2u r_length=30u
X59 a_n2994_6382.t1 a_n2514_260.t0 GND.t60 ppolyf_u_1k r_width=2u r_length=30u
X60 GND.t11 B04_OTA_0.Vbias1.t4 a_3334_4669.t5 GND.t10 nfet_03v3 ad=0.22p pd=1.88u as=0.22p ps=1.88u w=0.5u l=4u
X61 a_n3474_n2.t1 a_n2994_n6124.t0 GND.t23 ppolyf_u_1k r_width=2u r_length=30u
X62 a_1686_4337.t13 B04_OTA_0.Vin+.t4 a_2584_2555.t3 VDD.t30 pfet_03v3 ad=0.13p pd=1.02u as=0.13p ps=1.02u w=0.5u l=1u
X63 a_n9234_n2.t1 a_n8754_n6124.t0 GND.t52 ppolyf_u_1k r_width=2u r_length=30u
X64 GND.t20 GND.t21 GND.t19 ppolyf_u_1k r_width=2u r_length=30u
X65 VDD.t2 VDD.t0 VDD.t2 VDD.t1 pfet_03v3 ad=1.1p pd=5.88u as=0 ps=0 w=2.5u l=4u
X66 GND.t13 a_1974_4337.t9 a_1974_4669.t4 GND.t12 nfet_03v3 ad=0.22p pd=1.88u as=0.22p ps=1.88u w=0.5u l=4u
X67 a_n8274_n2.t1 a_n7794_n6124.t1 GND.t83 ppolyf_u_1k r_width=2u r_length=30u
X68 GND.t14 a_1974_4337.t7 a_2872_2967.t0 GND.t12 nfet_03v3 ad=0.22p pd=1.88u as=0.22p ps=1.88u w=0.5u l=4u
X69 a_2872_2555.t1 B04_OTA_0.Vbias2.t4 a_2584_2555.t1 GND.t15 nfet_03v3 ad=0.44p pd=2.88u as=0.44p ps=2.88u w=1u l=1u
X70 a_1686_4337.t16 B04_OTA_0.Vin+.t2 a_2584_2555.t4 VDD.t45 pfet_03v3 ad=0.22p pd=1.88u as=0.13p ps=1.02u w=0.5u l=1u
X71 GND.t47 GND.t45 GND.t47 GND.t46 nfet_03v3 ad=0.22p pd=1.88u as=0 ps=0 w=0.5u l=4u
X72 a_1974_4669.t7 B04_OTA_0.Vin+.t9 a_1686_4337.t11 VDD.t35 pfet_03v3 ad=0.13p pd=1.02u as=0.22p ps=1.88u w=0.5u l=1u
X73 VDD.t46 a_6034_5405.t5 a_6996_4337.t3 VDD.t23 pfet_03v3 ad=1.1p pd=5.88u as=1.1p ps=5.88u w=2.5u l=4u
X74 a_n7794_6382.t0 a_n8274_260.t1 GND.t83 ppolyf_u_1k r_width=2u r_length=30u
X75 a_3334_4669.t4 B04_OTA_0.Vbias1.t5 GND.t9 GND.t8 nfet_03v3 ad=0.22p pd=1.88u as=0.22p ps=1.88u w=0.5u l=4u
X76 GND.t51 GND.t50 GND.t51 GND.t46 nfet_03v3 ad=0.22p pd=1.88u as=0 ps=0 w=0.5u l=4u
X77 a_6034_5405.t2 B04_OTA_0.Vbias3.t5 a_6996_4337.t1 VDD.t26 pfet_03v3 ad=1.1p pd=5.88u as=1.1p ps=5.88u w=2.5u l=4u
X78 VDD.t15 VDD.t14 VDD.t15 VDD.t10 pfet_03v3 ad=0.22p pd=1.88u as=0 ps=0 w=0.5u l=1u
X79 a_1974_4669.t3 B04_OTA_0.Vbias1.t3 GND.t73 GND.t8 nfet_03v3 ad=0.22p pd=1.88u as=0.22p ps=1.88u w=0.5u l=4u
X80 B04_OTA_0.Vbias1.t1 B04_OTA_0.Vbias2.t2 a_3430_n2670.t1 GND.t62 nfet_03v3 ad=0.44p pd=2.88u as=0.44p ps=2.88u w=1u l=4u
X81 GND.t69 GND.t70 GND.t68 ppolyf_u_1k r_width=2u r_length=30u
X82 a_1974_4669.t9 B04_OTA_0.Vin+.t7 a_1686_4337.t15 VDD.t44 pfet_03v3 ad=0.13p pd=1.02u as=0.13p ps=1.02u w=0.5u l=1u
X83 a_n2034_6382.t1 VDD.t36 GND.t71 ppolyf_u_1k r_width=2u r_length=30u
X84 a_2872_2967.t1 B04_OTA_0.Vbias2.t10 a_1974_4337.t0 GND.t15 nfet_03v3 ad=0.44p pd=2.88u as=0.44p ps=2.88u w=1u l=1u
X85 B04_OTA_0.Vbias0.t1 B04_OTA_0.Vbias3.t2 a_6630_n1720.t0 VDD.t28 pfet_03v3 ad=2.2p pd=10.88u as=2.2p ps=10.88u w=5u l=4u
X86 VDD.t17 VDD.t16 VDD.t17 VDD.t1 pfet_03v3 ad=1.1p pd=5.88u as=0 ps=0 w=2.5u l=4u
X87 GND.t41 GND.t40 GND.t41 GND.t30 nfet_03v3 ad=0.44p pd=2.88u as=0 ps=0 w=1u l=1u
X88 a_n10674_6382.t0 a_n10194_260.t0 GND.t16 ppolyf_u_1k r_width=2u r_length=30u
X89 a_n2514_n2.t1 a_n2034_n6124.t0 GND.t61 ppolyf_u_1k r_width=2u r_length=30u
X90 a_n10674_6382.t1 B04_OTA_0.Vin+.t0 GND.t22 ppolyf_u_1k r_width=2u r_length=30u
X91 a_6034_5405.t0 B04_OTA_0.Vbias2.t7 a_1974_4669.t1 GND.t66 nfet_03v3 ad=0.22p pd=1.88u as=0.22p ps=1.88u w=0.5u l=4u
X92 a_1974_4337.t5 B04_OTA_0.Vin-.t7 a_1686_4337.t4 VDD.t35 pfet_03v3 ad=0.13p pd=1.02u as=0.22p ps=1.88u w=0.5u l=1u
X93 a_n4914_6382.t1 a_n4434_260.t0 GND.t72 ppolyf_u_1k r_width=2u r_length=30u
X94 B04_OTA_0.Vbias0.t0 VDD.t47 B04_OTA_0.Vbias3.t1 GND.t3 nfet_03v3 ad=4.4p pd=20.88u as=4.4p ps=20.88u w=10u l=4u
X95 a_n2514_n2.t0 a_n2994_n6124.t1 GND.t60 ppolyf_u_1k r_width=2u r_length=30u
X96 a_6996_4337.t0 B04_OTA_0.Vbias3.t4 a_6034_5405.t3 VDD.t23 pfet_03v3 ad=1.1p pd=5.88u as=1.1p ps=5.88u w=2.5u l=4u
X97 a_n4914_6382.t0 a_n5394_260.t0 GND.t55 ppolyf_u_1k r_width=2u r_length=30u
X98 GND.t81 GND.t82 GND.t68 ppolyf_u_1k r_width=2u r_length=30u
X99 a_3334_4669.t7 B04_OTA_0.Vin-.t9 a_1686_4337.t2 VDD.t29 pfet_03v3 ad=0.13p pd=1.02u as=0.13p ps=1.02u w=0.5u l=1u
X100 GND.t75 a_n2034_n6124.t1 GND.t71 ppolyf_u_1k r_width=2u r_length=30u
X101 GND.t34 GND.t32 GND.t34 GND.t33 nfet_03v3 ad=0.22p pd=1.88u as=0 ps=0 w=0.5u l=4u
X102 a_n7314_n2.t0 a_n7794_n6124.t0 GND.t58 ppolyf_u_1k r_width=2u r_length=30u
X103 GND.t31 GND.t29 GND.t31 GND.t30 nfet_03v3 ad=0.44p pd=2.88u as=0 ps=0 w=1u l=1u
X104 a_n7794_6382.t1 a_n7314_260.t1 GND.t58 ppolyf_u_1k r_width=2u r_length=30u
X105 a_1974_4337.t4 B04_OTA_0.Vin-.t5 a_1686_4337.t6 VDD.t44 pfet_03v3 ad=0.13p pd=1.02u as=0.13p ps=1.02u w=0.5u l=1u
X106 a_n6354_n2.t0 a_n6834_n6124.t0 GND.t0 ppolyf_u_1k r_width=2u r_length=30u
X107 a_1974_4669.t0 B04_OTA_0.Vbias2.t6 a_6034_5405.t1 GND.t76 nfet_03v3 ad=0.22p pd=1.88u as=0.22p ps=1.88u w=0.5u l=4u
X108 a_n7314_n2.t1 a_n6834_n6124.t1 GND.t54 ppolyf_u_1k r_width=2u r_length=30u
X109 a_1686_4337.t14 B04_OTA_0.Vin+.t6 a_1974_4669.t8 VDD.t31 pfet_03v3 ad=0.22p pd=1.88u as=0.13p ps=1.02u w=0.5u l=1u
X110 a_n5394_n2.t1 a_n5874_n6124.t1 GND.t56 ppolyf_u_1k r_width=2u r_length=30u
X111 B04_OTA_0.Vbias1.t0 GND.t86 B04_OTA_0.Vbias2.t1 VDD.t22 pfet_03v3 ad=2.2p pd=10.88u as=2.2p ps=10.88u w=5u l=4u
X112 a_n6354_260.t0 a_n5874_n6124.t0 GND.t7 ppolyf_u_1k r_width=2u r_length=30u
X113 VDD.t5 VDD.t3 VDD.t5 VDD.t4 pfet_03v3 ad=1.1p pd=5.88u as=0 ps=0 w=2.5u l=4u
X114 a_n3954_6382.t0 a_n3474_260.t1 GND.t57 ppolyf_u_1k r_width=2u r_length=30u
X115 a_2584_2555.t5 B04_OTA_0.Vin+.t3 a_1686_4337.t17 VDD.t29 pfet_03v3 ad=0.13p pd=1.02u as=0.13p ps=1.02u w=0.5u l=1u
R0 VbiasN VbiasN.t0 25.7454
R1 VDD.t39 VDD.t4 430.329
R2 VDD.t23 VDD.t39 430.329
R3 VDD.t26 VDD.t23 430.329
R4 VDD.t42 VDD.t26 430.329
R5 VDD.n40 VDD.n16 397.507
R6 VDD.n40 VDD.n17 388.978
R7 VDD.n43 VDD.n17 354.182
R8 VDD.n43 VDD.n16 346.622
R9 VDD.t10 VDD.t1 323.772
R10 VDD.t4 VDD.n40 258.87
R11 VDD.n41 VDD.t42 220.903
R12 VDD.n5 VDD.t28 209.439
R13 VDD.n7 VDD.t22 208.68
R14 VDD.n3 VDD.t37 184.632
R15 VDD.t7 VDD.t35 184.427
R16 VDD.t45 VDD.t10 183.607
R17 VDD.t31 VDD.t27 183.607
R18 VDD.t1 VDD.n42 160.246
R19 VDD.n43 VDD.t7 139.197
R20 VDD.t29 VDD.t45 124.591
R21 VDD.t30 VDD.t29 124.591
R22 VDD.t34 VDD.t44 124.591
R23 VDD.t35 VDD.t34 124.591
R24 VDD.t27 VDD.t24 95.9021
R25 VDD.t32 VDD.t31 90.9841
R26 VDD.n9 VDD.t20 52.4332
R27 VDD.n42 VDD.n41 49.1808
R28 VDD.n4 VDD.n3 47.281
R29 VDD.n3 VDD.n1 47.281
R30 VDD.t44 VDD.t32 33.6071
R31 VDD.t24 VDD.t30 28.689
R32 VDD.n9 VDD.n8 9.36311
R33 VDD.n2 VDD.t47 8.14522
R34 VDD.n26 VDD.t9 7.90225
R35 VDD.n29 VDD.t6 7.9013
R36 VDD.n28 VDD.t14 7.8695
R37 VDD.n31 VDD.t12 7.8695
R38 VDD.n37 VDD.n36 6.45853
R39 VDD.n12 VDD.t36 6.21289
R40 VDD.n26 VDD.t11 4.42237
R41 VDD.n27 VDD.t15 4.42237
R42 VDD.n29 VDD.t8 4.42191
R43 VDD.n30 VDD.t13 4.42191
R44 VDD.n33 VDD.n32 4.3205
R45 VDD.n10 VDD.n9 4.22332
R46 VDD.n22 VDD.t3 3.82424
R47 VDD.n14 VDD.t0 3.82424
R48 VDD.n25 VDD.t16 3.79275
R49 VDD.n24 VDD.t18 3.79275
R50 VDD.n4 VDD.n2 3.49093
R51 VDD.n46 VDD.t25 2.23238
R52 VDD.n45 VDD.t33 2.23023
R53 VDD.n38 VDD.t19 1.97684
R54 VDD.n35 VDD.t17 1.97684
R55 VDD.t19 VDD.n37 1.97376
R56 VDD.t17 VDD.n34 1.97376
R57 VDD.n19 VDD.t43 1.7685
R58 VDD.n19 VDD.t41 1.7685
R59 VDD.n18 VDD.t46 1.7685
R60 VDD.n18 VDD.t40 1.7685
R61 VDD.n11 VDD.n10 1.64165
R62 VDD VDD.n7 1.37198
R63 VDD.n39 VDD.n38 1.35607
R64 VDD.n8 VDD 1.33215
R65 VDD.n5 VDD.n4 1.22724
R66 VDD.n39 VDD.n23 1.18973
R67 VDD.n6 VDD.n5 0.964235
R68 VDD.n22 VDD.t5 0.885589
R69 VDD.n14 VDD.t2 0.885589
R70 VDD.n1 VDD.t38 0.8845
R71 VDD.n7 VDD.n6 0.620228
R72 VDD.n21 VDD.n20 0.483876
R73 VDD VDD.n45 0.336561
R74 VDD.n13 VDD.n12 0.33566
R75 VDD.n45 VDD.n44 0.319729
R76 VDD.n34 VDD.n33 0.301027
R77 VDD.n20 VDD.n19 0.270875
R78 VDD.n21 VDD.n18 0.270875
R79 VDD.n44 VDD.n43 0.263
R80 VDD.n40 VDD.n39 0.263
R81 VDD.n20 VDD.n0 0.262904
R82 VDD.n23 VDD.n21 0.259225
R83 VDD.n32 VDD.n13 0.2105
R84 VDD.n2 VDD.n1 0.176849
R85 VDD.n10 VDD.t21 0.171413
R86 VDD.n11 VDD.n8 0.139524
R87 VDD VDD.n46 0.11559
R88 VDD.n6 VDD.n1 0.113886
R89 VDD.n36 VDD.n35 0.11357
R90 VDD.n46 VDD 0.113288
R91 VDD VDD.n0 0.104081
R92 VDD.n27 VDD.n26 0.1001
R93 VDD.n30 VDD.n29 0.1001
R94 VDD.n44 VDD.n13 0.0963878
R95 VDD.n12 VDD.n11 0.0797727
R96 VDD.n33 VDD.n28 0.0791
R97 VDD.n32 VDD.n31 0.0791
R98 VDD.n23 VDD.n22 0.0743409
R99 VDD.n36 VDD.n17 0.0697308
R100 VDD.n41 VDD.n17 0.0697308
R101 VDD.n16 VDD.n15 0.0697308
R102 VDD.n42 VDD.n16 0.0697308
R103 VDD.n38 VDD.n24 0.0622419
R104 VDD.n35 VDD.n25 0.0622419
R105 VDD.n37 VDD.n24 0.0620047
R106 VDD.n34 VDD.n25 0.0620047
R107 VDD.n15 VDD.n14 0.0569545
R108 VDD.n28 VDD.n27 0.0323
R109 VDD.n31 VDD.n30 0.0323
R110 VDD.n15 VDD.n0 0.017375
R111 GND.n75 GND.n19 116844
R112 GND.n33 GND.n32 15383.3
R113 GND.n32 GND.n23 15383.3
R114 GND.n76 GND.n75 8415.46
R115 GND.n75 GND.n74 5109.45
R116 GND.n32 GND.n22 1709.89
R117 GND.n32 GND.n21 1281.94
R118 GND.n17 GND.n5 1154.03
R119 GND.t79 GND.t67 708.587
R120 GND.t4 GND.t76 708.587
R121 GND.t64 GND.t33 708.587
R122 GND.n78 GND.n77 554.556
R123 GND.t30 GND.t64 540.067
R124 GND.t36 GND.n19 458.755
R125 GND.n51 GND.n20 454.3
R126 GND.n74 GND.t43 453.353
R127 GND.t46 GND.n21 451.45
R128 GND.n51 GND.n36 446.601
R129 GND.n73 GND.n36 378.7
R130 GND.n23 GND.t8 378.401
R131 GND.n73 GND.n20 371
R132 GND.n23 GND.t66 330.188
R133 GND.t15 GND.t77 327.988
R134 GND.n35 GND.t78 322.882
R135 GND.n34 GND.t10 305.349
R136 GND.n21 GND.t36 257.137
R137 GND.n22 GND.t27 231.779
R138 GND.t12 GND.t30 225.948
R139 GND.n32 GND.t62 192.951
R140 GND.n31 GND.t3 177.876
R141 GND.n80 GND.t3 177.876
R142 GND.n79 GND.t1 177.876
R143 GND.n76 GND.t1 177.876
R144 GND.n81 GND.n3 165.667
R145 GND.t62 GND.n31 144.713
R146 GND.n75 GND.n18 122.707
R147 GND.t71 GND.t68 118.272
R148 GND.t61 GND.t71 118.272
R149 GND.t60 GND.t61 118.272
R150 GND.t23 GND.t60 118.272
R151 GND.t57 GND.t23 118.272
R152 GND.t59 GND.t57 118.272
R153 GND.t72 GND.t59 118.272
R154 GND.t55 GND.t72 118.272
R155 GND.t56 GND.t55 118.272
R156 GND.t7 GND.t56 118.272
R157 GND.t0 GND.t7 118.272
R158 GND.t54 GND.t0 118.272
R159 GND.t58 GND.t54 118.272
R160 GND.t83 GND.t58 118.272
R161 GND.t53 GND.t83 118.272
R162 GND.t52 GND.t53 118.272
R163 GND.t18 GND.t52 118.272
R164 GND.t17 GND.t18 118.272
R165 GND.t16 GND.t17 118.272
R166 GND.t22 GND.t16 118.272
R167 GND.t19 GND.t22 118.272
R168 GND.n80 GND.n79 105.519
R169 GND.t77 GND.t12 102.041
R170 GND.n22 GND.t15 96.2104
R171 GND.n5 GND.t19 92.6847
R172 GND.n18 GND.t68 92.6464
R173 GND.n35 GND.n34 80.3556
R174 GND.t67 GND.t46 58.4406
R175 GND.t76 GND.t79 58.4406
R176 GND.t66 GND.t4 58.4406
R177 GND.t8 GND.t78 58.4406
R178 GND.n33 GND.t33 35.0646
R179 GND.t10 GND.n33 23.3765
R180 GND.n11 GND.n10 19.7148
R181 GND.n67 GND.t29 9.74426
R182 GND.n37 GND.t38 9.70368
R183 GND.n37 GND.t26 9.70093
R184 GND.n70 GND.t40 9.6945
R185 GND.n57 GND.t51 9.58962
R186 GND.n57 GND.t47 9.58962
R187 GND.n59 GND.t51 9.58587
R188 GND.n59 GND.t47 9.58587
R189 GND.t49 GND.n64 9.58025
R190 GND.n64 GND.t44 9.58025
R191 GND.n65 GND.t44 9.5765
R192 GND.n65 GND.t49 9.5765
R193 GND.n46 GND.t5 9.5765
R194 GND.n46 GND.t80 9.5765
R195 GND.n47 GND.t6 9.5765
R196 GND.n47 GND.t85 9.5765
R197 GND.n44 GND.t84 9.5765
R198 GND.n44 GND.t9 9.5765
R199 GND.n45 GND.t11 9.5765
R200 GND.n45 GND.t73 9.5765
R201 GND.n42 GND.t13 9.5765
R202 GND.n42 GND.t74 9.5765
R203 GND.n43 GND.t14 9.5765
R204 GND.n43 GND.t65 9.5765
R205 GND.n50 GND.n48 8.5805
R206 GND.t27 GND.t43 7.28913
R207 GND.n48 GND.n40 6.7655
R208 GND.n30 GND.t63 5.68598
R209 GND.n6 GND.n0 5.42319
R210 GND.n38 GND.t39 4.79493
R211 GND.t28 GND.n38 4.79493
R212 GND.n49 GND.t37 4.789
R213 GND.n66 GND.t34 4.789
R214 GND.n39 GND.t28 4.7885
R215 GND.n39 GND.t39 4.7885
R216 GND.n26 GND.t86 4.74041
R217 GND.n54 GND.n53 4.47312
R218 GND.n84 GND.n83 4.42102
R219 GND.n14 GND.t75 4.0576
R220 GND.n12 GND.t70 3.57
R221 GND.n15 GND.t81 3.57
R222 GND.n13 GND.t82 3.57
R223 GND.n10 GND.t20 3.57
R224 GND.n9 GND.t21 3.57
R225 GND.n7 GND.t24 3.57
R226 GND.n6 GND.t25 3.57
R227 GND.n11 GND.t69 3.57
R228 GND.n55 GND.n4 3.5239
R229 GND.n27 GND.n24 2.55915
R230 GND.n25 GND.n24 2.55915
R231 GND.n68 GND.t31 2.40358
R232 GND.n69 GND.t41 2.3984
R233 GND.n83 GND.n1 2.24034
R234 GND.n29 GND.n28 2.1876
R235 GND.n49 GND.t35 2.12328
R236 GND.n66 GND.t32 2.12328
R237 GND.n58 GND.t45 1.96933
R238 GND.n41 GND.t42 1.9682
R239 GND.n41 GND.t48 1.96775
R240 GND.n58 GND.t50 1.96775
R241 GND.n71 GND.n70 1.7455
R242 GND.n56 GND.n52 1.70332
R243 GND.n71 GND.n65 1.47702
R244 GND.n27 GND.n26 1.38792
R245 GND.n14 GND.n13 1.32838
R246 GND.n12 GND.n11 1.32256
R247 GND.n10 GND.n9 1.29231
R248 GND.n7 GND.n6 1.29231
R249 GND.n26 GND.n25 1.28485
R250 GND.n67 GND.n66 1.27181
R251 GND.n55 GND.n54 1.15079
R252 GND.n53 GND.n1 1.04767
R253 GND.n30 GND.n29 1.0357
R254 GND.n52 GND.n50 1.0355
R255 GND.n84 GND.n0 0.947098
R256 GND.t62 GND.n30 0.861176
R257 GND.n61 GND.n60 0.820283
R258 GND.n63 GND 0.80463
R259 GND GND.n84 0.583908
R260 GND.n56 GND.n55 0.466812
R261 GND.n60 GND.n59 0.44463
R262 GND.n64 GND.n63 0.440717
R263 GND.n28 GND.n27 0.313543
R264 GND.n50 GND.n49 0.309568
R265 GND.n53 GND.n3 0.226587
R266 GND.n31 GND.n3 0.226587
R267 GND.n82 GND.n81 0.226587
R268 GND.n81 GND.n80 0.226587
R269 GND.n73 GND.n72 0.217167
R270 GND.n74 GND.n73 0.217167
R271 GND.n52 GND.n51 0.217167
R272 GND.n51 GND.n19 0.217167
R273 GND.n60 GND.n47 0.202864
R274 GND.n62 GND.n45 0.202864
R275 GND.n63 GND.n43 0.202864
R276 GND.n72 GND.n40 0.1805
R277 GND.n47 GND.n46 0.177496
R278 GND.n45 GND.n44 0.177496
R279 GND.n43 GND.n42 0.177496
R280 GND.n83 GND.n82 0.175366
R281 GND.n54 GND.n2 0.153074
R282 GND.n13 GND.n0 0.148734
R283 GND.n69 GND.n68 0.140328
R284 GND.n72 GND.n71 0.1355
R285 GND.n2 GND.t2 0.092694
R286 GND.n28 GND.n1 0.0898576
R287 GND.n29 GND.n25 0.0885435
R288 GND.n48 GND.n20 0.0758623
R289 GND.n34 GND.n20 0.0758623
R290 GND.n61 GND.n36 0.0758623
R291 GND.n36 GND.n35 0.0758623
R292 GND.n4 GND 0.0641364
R293 GND.n40 GND.n39 0.0631087
R294 GND.n70 GND.n69 0.0525
R295 GND.n78 GND.n2 0.0486481
R296 GND.n79 GND.n78 0.0486481
R297 GND.n77 GND.n4 0.0486481
R298 GND.n77 GND.n76 0.0486481
R299 GND.n65 GND.n41 0.0433211
R300 GND.n64 GND.n41 0.0429421
R301 GND.n59 GND.n58 0.0428191
R302 GND.n58 GND.n57 0.0424362
R303 GND.n17 GND.n16 0.0387353
R304 GND.n18 GND.n17 0.0387353
R305 GND.n8 GND.n5 0.0387353
R306 GND.n82 GND.n2 0.0309813
R307 GND.n57 GND.n56 0.0278913
R308 GND.n9 GND.n8 0.022686
R309 GND.n8 GND.n7 0.022686
R310 GND.n16 GND.n12 0.022686
R311 GND.n16 GND.n15 0.022686
R312 GND.t62 GND.n24 0.0219245
R313 GND.n39 GND.n37 0.0203261
R314 GND.n38 GND.n37 0.0185
R315 GND GND.n62 0.0181087
R316 GND.n68 GND.n67 0.00300333
R317 GND.n62 GND.n61 0.00245652
R318 GND.n15 GND.n14 0.00175581
R319 a_3430_n2670.t0 a_3430_n2670.t1 18.9702
R320 a_6630_n1720.t0 a_6630_n1720.t1 2.98682
R321 B04_OTA_0.Vbias1.t1 B04_OTA_0.Vbias1.n4 9.2885
R322 B04_OTA_0.Vbias1.n0 B04_OTA_0.Vbias1.n4 1.3405
R323 B04_OTA_0.Vbias1 B04_OTA_0.Vbias1.n0 0.7105
R324 B04_OTA_0.Vbias1 B04_OTA_0.Vbias1.n1 4.58413
R325 B04_OTA_0.Vbias1.n1 B04_OTA_0.Vbias1.n2 0.3389
R326 B04_OTA_0.Vbias1.n2 B04_OTA_0.Vbias1 0.313379
R327 B04_OTA_0.Vbias1.n3 B04_OTA_0.Vbias1 0.388212
R328 B04_OTA_0.Vbias1.n3 B04_OTA_0.Vbias1.t3 2.30615
R329 B04_OTA_0.Vbias1.t5 B04_OTA_0.Vbias1.n3 1.96775
R330 B04_OTA_0.Vbias1.n1 B04_OTA_0.Vbias1.t4 1.96775
R331 B04_OTA_0.Vbias1.n2 B04_OTA_0.Vbias1.t6 1.96775
R332 B04_OTA_0.Vbias1.n4 B04_OTA_0.Vbias1.t2 6.30681
R333 B04_OTA_0.Vbias1.n0 B04_OTA_0.Vbias1.t0 1.45647
R334 a_2872_2555.t0 a_2872_2555.n1 11.919
R335 a_2872_2555.n1 a_2872_2555.t3 22.2545
R336 a_2872_2555.n1 a_2872_2555.n0 4.27057
R337 a_2872_2555.n0 a_2872_2555.t1 9.6245
R338 a_2872_2555.n0 a_2872_2555.t2 9.4465
R339 a_2872_2967.t0 a_2872_2967.n1 11.909
R340 a_2872_2967.n1 a_2872_2967.n0 5.949
R341 a_2872_2967.n0 a_2872_2967.t1 5.58984
R342 a_2872_2967.n0 a_2872_2967.t3 4.7885
R343 a_2872_2967.n1 a_2872_2967.t2 13.3895
R344 B04_OTA_0.Vbias2.n12 B04_OTA_0.Vbias2.t1 1.38924
R345 B04_OTA_0.Vbias2.n0 B04_OTA_0.Vbias2.n12 0.001625
R346 B04_OTA_0.Vbias2.n0 B04_OTA_0.Vbias2.t2 4.92682
R347 B04_OTA_0.Vbias2.n12 B04_OTA_0.Vbias2.n11 0.339817
R348 B04_OTA_0.Vbias2 B04_OTA_0.Vbias2.n11 0.0489615
R349 B04_OTA_0.Vbias2.n11 B04_OTA_0.Vbias2.n10 0.2155
R350 B04_OTA_0.Vbias2.n11 B04_OTA_0.Vbias2 0.0355
R351 B04_OTA_0.Vbias2 B04_OTA_0.Vbias2.n9 7.15014
R352 B04_OTA_0.Vbias2.n10 B04_OTA_0.Vbias2.n0 0.0212692
R353 B04_OTA_0.Vbias2.n10 B04_OTA_0.Vbias2.t0 5.96884
R354 B04_OTA_0.Vbias2.n9 B04_OTA_0.Vbias2.n6 1.51812
R355 B04_OTA_0.Vbias2.n6 B04_OTA_0.Vbias2.n7 0.414549
R356 B04_OTA_0.Vbias2.n7 B04_OTA_0.Vbias2.n8 0.414549
R357 B04_OTA_0.Vbias2.t5 B04_OTA_0.Vbias2.n8 2.3818
R358 B04_OTA_0.Vbias2.t6 B04_OTA_0.Vbias2.n8 1.96775
R359 B04_OTA_0.Vbias2.t7 B04_OTA_0.Vbias2.n7 1.96775
R360 B04_OTA_0.Vbias2.t8 B04_OTA_0.Vbias2.n6 1.96775
R361 B04_OTA_0.Vbias2.n1 B04_OTA_0.Vbias2.n5 0.00584247
R362 B04_OTA_0.Vbias2.n5 B04_OTA_0.Vbias2.n9 1.25132
R363 B04_OTA_0.Vbias2.n2 B04_OTA_0.Vbias2.n5 0.883574
R364 B04_OTA_0.Vbias2.n3 B04_OTA_0.Vbias2.n2 0.552762
R365 B04_OTA_0.Vbias2.n3 B04_OTA_0.Vbias2.n4 0.894055
R366 B04_OTA_0.Vbias2.n4 B04_OTA_0.Vbias2 0.085774
R367 B04_OTA_0.Vbias2 B04_OTA_0.Vbias2.n1 0.122774
R368 B04_OTA_0.Vbias2.t10 B04_OTA_0.Vbias2.n4 9.6945
R369 B04_OTA_0.Vbias2.n3 B04_OTA_0.Vbias2.t4 9.6945
R370 B04_OTA_0.Vbias2.n2 B04_OTA_0.Vbias2.t3 9.6945
R371 B04_OTA_0.Vbias2.t9 B04_OTA_0.Vbias2.n1 9.6945
R372 a_2584_2555.t1 a_2584_2555.n0 19.5078
R373 a_2584_2555.n0 a_2584_2555.n4 0.26375
R374 a_2584_2555.n4 a_2584_2555.n7 1.3705
R375 a_2584_2555.n7 a_2584_2555.n6 7.75965
R376 a_2584_2555.n6 a_2584_2555.t2 3.6405
R377 a_2584_2555.n6 a_2584_2555.t3 3.6405
R378 a_2584_2555.n7 a_2584_2555.n5 7.73715
R379 a_2584_2555.n5 a_2584_2555.t5 3.6405
R380 a_2584_2555.n5 a_2584_2555.t4 3.6405
R381 a_2584_2555.n4 a_2584_2555.n1 6.14811
R382 a_2584_2555.n1 a_2584_2555.n3 0.00956977
R383 a_2584_2555.n3 a_2584_2555.t7 2.29235
R384 a_2584_2555.n3 a_2584_2555.n2 0.728816
R385 a_2584_2555.n2 a_2584_2555.t6 2.30615
R386 a_2584_2555.n2 a_2584_2555.t8 1.96775
R387 a_2584_2555.n1 a_2584_2555.t9 1.96775
R388 a_2584_2555.n0 a_2584_2555.t0 9.3205
R389 a_1974_4337.t1 a_1974_4337.n3 9.3925
R390 a_1974_4337.n3 a_1974_4337.n7 10.5834
R391 a_1974_4337.n7 a_1974_4337.n6 1.563
R392 a_1974_4337.n6 a_1974_4337.n5 7.73715
R393 a_1974_4337.n5 a_1974_4337.t5 3.6405
R394 a_1974_4337.n5 a_1974_4337.t3 3.6405
R395 a_1974_4337.n6 a_1974_4337.n4 7.75965
R396 a_1974_4337.n4 a_1974_4337.t4 3.6405
R397 a_1974_4337.n4 a_1974_4337.t2 3.6405
R398 a_1974_4337.n7 a_1974_4337.t0 9.3156
R399 a_1974_4337.n2 a_1974_4337.n0 0.0251
R400 a_1974_4337.n3 a_1974_4337.n2 5.0755
R401 a_1974_4337.n2 a_1974_4337.n1 0.676491
R402 a_1974_4337.n1 a_1974_4337.t6 2.30615
R403 a_1974_4337.n1 a_1974_4337.t8 1.96775
R404 a_1974_4337.n0 a_1974_4337.t7 2.30615
R405 a_1974_4337.n0 a_1974_4337.t9 1.96775
R406 a_3334_4669.t1 a_3334_4669.n7 11.909
R407 a_3334_4669.n7 a_3334_4669.n6 0.548
R408 a_3334_4669.n6 a_3334_4669.t5 13.3865
R409 a_3334_4669.n6 a_3334_4669.t4 11.912
R410 a_3334_4669.n7 a_3334_4669.n0 1.4105
R411 a_3334_4669.n0 a_3334_4669.n5 1.4505
R412 a_3334_4669.n0 a_3334_4669.t0 11.912
R413 a_3334_4669.n5 a_3334_4669.t2 10.9074
R414 a_3334_4669.n5 a_3334_4669.n1 2.90636
R415 a_3334_4669.n1 a_3334_4669.n4 4.63898
R416 a_3334_4669.n4 a_3334_4669.n3 7.455
R417 a_3334_4669.n3 a_3334_4669.t7 3.6405
R418 a_3334_4669.n3 a_3334_4669.t9 3.6405
R419 a_3334_4669.n4 a_3334_4669.n2 8.13
R420 a_3334_4669.n2 a_3334_4669.t6 3.6405
R421 a_3334_4669.n2 a_3334_4669.t8 3.6405
R422 a_3334_4669.n1 a_3334_4669.t3 9.60702
R423 a_1974_4669.t3 a_1974_4669.n7 16.8845
R424 a_1974_4669.n7 a_1974_4669.n1 0.578
R425 a_1974_4669.n1 a_1974_4669.n6 0.812911
R426 a_1974_4669.n6 a_1974_4669.n2 0.797375
R427 a_1974_4669.n2 a_1974_4669.n5 4.34201
R428 a_1974_4669.n5 a_1974_4669.n4 7.75232
R429 a_1974_4669.n4 a_1974_4669.t9 3.6405
R430 a_1974_4669.n4 a_1974_4669.t8 3.6405
R431 a_1974_4669.n5 a_1974_4669.n3 7.75232
R432 a_1974_4669.n3 a_1974_4669.t7 3.6405
R433 a_1974_4669.n3 a_1974_4669.t6 3.6405
R434 a_1974_4669.n2 a_1974_4669.t4 16.7127
R435 a_1974_4669.n6 a_1974_4669.t5 16.7214
R436 a_1974_4669.n1 a_1974_4669.t2 16.7127
R437 a_1974_4669.n7 a_1974_4669.n0 7.72523
R438 a_1974_4669.n0 a_1974_4669.t1 9.96114
R439 a_1974_4669.n0 a_1974_4669.t0 11.8103
R440 B04_OTA_0.Vbias3.n0 B04_OTA_0.Vbias3.t1 0.7143
R441 B04_OTA_0.Vbias3.n4 B04_OTA_0.Vbias3.n0 4.80616
R442 B04_OTA_0.Vbias3 B04_OTA_0.Vbias3.n4 0.0337609
R443 B04_OTA_0.Vbias3 B04_OTA_0.Vbias3.n3 9.46529
R444 B04_OTA_0.Vbias3 B04_OTA_0.Vbias3.n3 0.0271667
R445 B04_OTA_0.Vbias3.n3 B04_OTA_0.Vbias3.n1 0.0231667
R446 B04_OTA_0.Vbias3.n1 B04_OTA_0.Vbias3.n2 0.738985
R447 B04_OTA_0.Vbias3.n2 B04_OTA_0.Vbias3.t3 4.53124
R448 B04_OTA_0.Vbias3.n2 B04_OTA_0.Vbias3.t4 3.79275
R449 B04_OTA_0.Vbias3 B04_OTA_0.Vbias3.t6 4.4819
R450 B04_OTA_0.Vbias3.n1 B04_OTA_0.Vbias3.t5 3.79275
R451 B04_OTA_0.Vbias3.n4 B04_OTA_0.Vbias3.t2 3.60877
R452 B04_OTA_0.Vbias3.n0 B04_OTA_0.Vbias3.t0 0.49139
R453 B04_OTA_0.Vin- B04_OTA_0.Vin-.t1 14.3449
R454 B04_OTA_0.Vin- B04_OTA_0.Vin-.n0 0.9155
R455 B04_OTA_0.Vin-.n1 B04_OTA_0.Vin-.n2 0.2735
R456 B04_OTA_0.Vin-.n0 B04_OTA_0.Vin-.n1 2.08891
R457 B04_OTA_0.Vin-.n2 B04_OTA_0.Vin-.n10 8.2705
R458 B04_OTA_0.Vin-.n10 B04_OTA_0.Vin-.n9 7.68688
R459 B04_OTA_0.Vin-.n9 B04_OTA_0.Vin-.n6 0.239602
R460 B04_OTA_0.Vin-.n6 B04_OTA_0.Vin-.n7 0.247398
R461 B04_OTA_0.Vin-.n7 B04_OTA_0.Vin- 0.159949
R462 B04_OTA_0.Vin- B04_OTA_0.Vin-.n8 0.0185
R463 B04_OTA_0.Vin- B04_OTA_0.Vin-.n8 0.0132559
R464 B04_OTA_0.Vin-.t8 B04_OTA_0.Vin-.n8 7.93895
R465 B04_OTA_0.Vin-.n7 B04_OTA_0.Vin-.t9 7.8695
R466 B04_OTA_0.Vin-.n6 B04_OTA_0.Vin-.t10 7.8695
R467 B04_OTA_0.Vin-.n9 B04_OTA_0.Vin-.t11 7.87729
R468 B04_OTA_0.Vin-.n10 B04_OTA_0.Vin-.n5 6.94663
R469 B04_OTA_0.Vin-.n5 B04_OTA_0.Vin-.n3 0.2417
R470 B04_OTA_0.Vin-.n3 B04_OTA_0.Vin-.n4 0.24962
R471 B04_OTA_0.Vin-.n4 B04_OTA_0.Vin-.t7 8.11862
R472 B04_OTA_0.Vin-.n4 B04_OTA_0.Vin-.t6 7.8695
R473 B04_OTA_0.Vin-.n3 B04_OTA_0.Vin-.t5 7.8695
R474 B04_OTA_0.Vin-.n5 B04_OTA_0.Vin-.t4 7.87742
R475 B04_OTA_0.Vin-.n2 B04_OTA_0.Vin-.t0 15.0048
R476 B04_OTA_0.Vin-.n1 B04_OTA_0.Vin-.t2 2.89471
R477 B04_OTA_0.Vin-.n0 B04_OTA_0.Vin-.t3 2.89478
R478 a_6996_4337.t0 a_6996_4337.n0 5.47625
R479 a_6996_4337.n0 a_6996_4337.n1 4.89331
R480 a_6996_4337.n1 a_6996_4337.t3 1.7685
R481 a_6996_4337.n1 a_6996_4337.t2 1.7685
R482 a_6996_4337.n0 a_6996_4337.t1 5.43834
R483 a_5946_4337.t1 a_5946_4337.n0 3.76471
R484 a_5946_4337.n0 a_5946_4337.n1 2.64693
R485 a_5946_4337.n1 a_5946_4337.t0 3.76478
R486 a_5946_4337.n1 a_5946_4337.t3 2.89478
R487 a_5946_4337.n0 a_5946_4337.t2 2.89471
R488 a_1686_4337.t3 a_1686_4337.n0 9.0355
R489 a_1686_4337.n11 a_1686_4337.n5 0.66425
R490 a_1686_4337.n0 a_1686_4337.n11 0.68675
R491 a_1686_4337.n11 a_1686_4337.n10 5.3955
R492 a_1686_4337.n10 a_1686_4337.t1 3.6405
R493 a_1686_4337.n10 a_1686_4337.t2 3.6405
R494 a_1686_4337.n11 a_1686_4337.n9 5.38441
R495 a_1686_4337.n9 a_1686_4337.t13 3.6405
R496 a_1686_4337.n9 a_1686_4337.t17 3.6405
R497 a_1686_4337.n5 a_1686_4337.n7 0.0824886
R498 a_1686_4337.n5 a_1686_4337.n6 0.0855
R499 a_1686_4337.n6 a_1686_4337.n8 1.8853
R500 a_1686_4337.n8 a_1686_4337.t9 0.7285
R501 a_1686_4337.n8 a_1686_4337.t8 0.7285
R502 a_1686_4337.n7 a_1686_4337.t12 8.8405
R503 a_1686_4337.n7 a_1686_4337.t7 8.8405
R504 a_1686_4337.n6 a_1686_4337.t0 8.8405
R505 a_1686_4337.n6 a_1686_4337.t14 8.8405
R506 a_1686_4337.n3 a_1686_4337.n4 0.68675
R507 a_1686_4337.n5 a_1686_4337.n3 0.66425
R508 a_1686_4337.n4 a_1686_4337.t11 9.0355
R509 a_1686_4337.n4 a_1686_4337.t4 9.02441
R510 a_1686_4337.n3 a_1686_4337.n2 5.3955
R511 a_1686_4337.n2 a_1686_4337.t10 3.6405
R512 a_1686_4337.n2 a_1686_4337.t15 3.6405
R513 a_1686_4337.n3 a_1686_4337.n1 5.38441
R514 a_1686_4337.n1 a_1686_4337.t5 3.6405
R515 a_1686_4337.n1 a_1686_4337.t6 3.6405
R516 a_1686_4337.n0 a_1686_4337.t16 9.02441
R517 a_6034_5405.t1 a_6034_5405.n0 9.6215
R518 a_6034_5405.n0 a_6034_5405.n1 9.98253
R519 a_6034_5405.n1 a_6034_5405.n4 0.417688
R520 a_6034_5405.n4 a_6034_5405.n3 0.29245
R521 a_6034_5405.n3 a_6034_5405.t7 4.51885
R522 a_6034_5405.n3 a_6034_5405.t6 3.79275
R523 a_6034_5405.n4 a_6034_5405.n2 0.29065
R524 a_6034_5405.n2 a_6034_5405.t4 4.51885
R525 a_6034_5405.n2 a_6034_5405.t5 3.79275
R526 a_6034_5405.n1 a_6034_5405.t3 1.7685
R527 a_6034_5405.n1 a_6034_5405.t2 1.7685
R528 a_6034_5405.n0 a_6034_5405.t0 9.6191
R529 B04_OTA_0.Vbias0.t1 B04_OTA_0.Vbias0.n0 4.15757
R530 B04_OTA_0.Vbias0.n1 B04_OTA_0.Vbias0.n0 0.913604
R531 B04_OTA_0.Vbias0 B04_OTA_0.Vbias0.n1 0.223769
R532 B04_OTA_0.Vbias0 B04_OTA_0.Vbias0.n2 8.17958
R533 B04_OTA_0.Vbias0 B04_OTA_0.Vbias0.n4 0.0692898
R534 B04_OTA_0.Vbias0.n2 B04_OTA_0.Vbias0.n4 0.228653
R535 B04_OTA_0.Vbias0 B04_OTA_0.Vbias0.n3 0.0095
R536 B04_OTA_0.Vbias0.n4 B04_OTA_0.Vbias0.n3 0.0815
R537 B04_OTA_0.Vbias0 B04_OTA_0.Vbias0.n3 0.00737898
R538 B04_OTA_0.Vbias0.t4 B04_OTA_0.Vbias0 4.01402
R539 B04_OTA_0.Vbias0.n2 B04_OTA_0.Vbias0.t3 3.79275
R540 B04_OTA_0.Vbias0.n1 B04_OTA_0.Vbias0.t2 3.35948
R541 B04_OTA_0.Vbias0.n0 B04_OTA_0.Vbias0.t0 0.7143
R542 a_n2034_n6124.t0 a_n2034_n6124.t1 7.62565
R543 a_n2514_n2.t0 a_n2514_n2.t1 7.64366
R544 a_n2994_n6124.t0 a_n2994_n6124.t1 7.62565
R545 a_n3474_n2.t0 a_n3474_n2.t1 7.64366
R546 a_n3954_n6124.t0 a_n3954_n6124.t1 7.62565
R547 a_n4434_n2.t0 a_n4434_n2.t1 7.64366
R548 a_n4914_n6124.t0 a_n4914_n6124.t1 7.62565
R549 a_n5394_n2.t0 a_n5394_n2.t1 7.64366
R550 a_n5874_n6124.t0 a_n5874_n6124.t1 7.62565
R551 a_n6834_n6124.t0 a_n6834_n6124.t1 7.62565
R552 a_n7314_n2.t0 a_n7314_n2.t1 7.64366
R553 a_n7794_n6124.t0 a_n7794_n6124.t1 7.62565
R554 a_n8274_n2.t0 a_n8274_n2.t1 7.64366
R555 a_n8754_n6124.t0 a_n8754_n6124.t1 7.62565
R556 a_n9234_n2.t0 a_n9234_n2.t1 7.64366
R557 a_n9714_n6124.t0 a_n9714_n6124.t1 7.62565
R558 a_n10194_n2.t0 a_n10194_n2.t1 7.64366
R559 a_n10674_n6124.t0 a_n10674_n6124.t1 7.62565
R560 a_n2034_6382.t0 a_n2034_6382.t1 7.62565
R561 a_n2514_260.t0 a_n2514_260.t1 7.60142
R562 a_n2994_6382.t0 a_n2994_6382.t1 7.62565
R563 a_n3474_260.t0 a_n3474_260.t1 7.60142
R564 a_n3954_6382.t0 a_n3954_6382.t1 7.62565
R565 a_n4434_260.t0 a_n4434_260.t1 7.60142
R566 a_n4914_6382.t0 a_n4914_6382.t1 7.674
R567 a_n5394_260.t0 a_n5394_260.t1 7.60142
R568 a_n6354_n2.t0 a_n6354_n2.t1 7.5297
R569 a_n5874_6382.t0 a_n5874_6382.t1 7.62565
R570 a_n6354_260.t0 a_n6354_260.t1 10.4204
R571 a_n6834_6382.t0 a_n6834_6382.t1 7.62565
R572 a_n7314_260.t0 a_n7314_260.t1 7.60142
R573 a_n7794_6382.t0 a_n7794_6382.t1 7.62565
R574 a_n8274_260.t0 a_n8274_260.t1 7.60142
R575 a_n8754_6382.t0 a_n8754_6382.t1 7.62565
R576 a_n9234_260.t0 a_n9234_260.t1 7.60142
R577 a_n9714_6382.t0 a_n9714_6382.t1 7.62565
R578 a_n10194_260.t0 a_n10194_260.t1 7.60142
R579 B04_OTA_0.Vin+.n0 B04_OTA_0.Vin+.t0 3.57
R580 B04_OTA_0.Vin+.n5 B04_OTA_0.Vin+.n0 15.8756
R581 B04_OTA_0.Vin+.n4 B04_OTA_0.Vin+.n5 2.2505
R582 B04_OTA_0.Vin+.n5 B04_OTA_0.Vin+.n8 3.30425
R583 B04_OTA_0.Vin+.n8 B04_OTA_0.Vin+.n6 0.2417
R584 B04_OTA_0.Vin+.n6 B04_OTA_0.Vin+.n7 0.24962
R585 B04_OTA_0.Vin+.n7 B04_OTA_0.Vin+.t2 8.11862
R586 B04_OTA_0.Vin+.n7 B04_OTA_0.Vin+.t3 7.8695
R587 B04_OTA_0.Vin+.n6 B04_OTA_0.Vin+.t4 7.8695
R588 B04_OTA_0.Vin+.n8 B04_OTA_0.Vin+.t5 7.87742
R589 B04_OTA_0.Vin+.n1 B04_OTA_0.Vin+.n4 0.239602
R590 B04_OTA_0.Vin+.n2 B04_OTA_0.Vin+.n1 0.247398
R591 B04_OTA_0.Vin+ B04_OTA_0.Vin+.n3 0.0529409
R592 B04_OTA_0.Vin+.n3 B04_OTA_0.Vin+.n2 0.247398
R593 B04_OTA_0.Vin+.n3 B04_OTA_0.Vin+.t9 7.8695
R594 B04_OTA_0.Vin+.n2 B04_OTA_0.Vin+.t8 7.8695
R595 B04_OTA_0.Vin+.n1 B04_OTA_0.Vin+.t7 7.8695
R596 B04_OTA_0.Vin+.n4 B04_OTA_0.Vin+.t6 7.87729
R597 B04_OTA_0.Vin+.n0 B04_OTA_0.Vin+.t1 3.57
R598 a_n10674_6382.t0 a_n10674_6382.t1 7.62565
C0 B04_OTA_0.Vbias3 VDD 9.90638f
C1 B04_OTA_0.Vin- VDD 3.46388f
C2 B04_OTA_0.Vbias2 B04_OTA_bias_ratio_5_0.VbiasP 1.51197f
C3 B04_OTA_0.Vbias3 B04_OTA_0.Vbias0 1.82312f
C4 B04_OTA_0.Vin+ VDD 3.78297f
C5 B04_OTA_0.Vbias0 VDD 10.2159f
C6 B04_OTA_0.Vbias2 VDD 4.55195f
C7 B04_OTA_0.Vbias3 VbiasN 4.72647f
C8 B04_OTA_0.Vbias3 B04_OTA_0.Vin- 1.2979f
C9 VDD B04_OTA_bias_ratio_5_0.VbiasP 4.52766f
C10 VbiasN GND 9.42279f
C11 VDD GND 0.14125p
C12 B04_OTA_0.Vbias1 GND 10.43551f
C13 B04_OTA_0.Vbias2 GND 19.24237f
C14 B04_OTA_0.Vbias3 GND 15.13956f
C15 B04_OTA_0.Vin- GND 2.07321f
C16 B04_OTA_0.Vbias0 GND 9.2374f
C17 B04_OTA_0.Vin+ GND 6.60537f
C18 B04_OTA_0.Vin+.n0 GND 3.78061f
C19 B04_OTA_0.Vin+.n5 GND 3.14873f
C20 B04_OTA_0.Vbias0.n0 GND 1.62044f
C21 B04_OTA_0.Vbias0.t2 GND 1.23693f
C22 B04_OTA_0.Vbias0.n1 GND 2.14248f
C23 B04_OTA_0.Vbias0.n2 GND 3.16183f
C24 a_6034_5405.t5 GND 1.12919f
C25 a_6034_5405.n2 GND 1.43068f
C26 a_6034_5405.t4 GND 1.26139f
C27 a_6034_5405.t6 GND 1.12919f
C28 a_6034_5405.n3 GND 1.43019f
C29 a_6034_5405.t7 GND 1.26117f
C30 a_5946_4337.n0 GND 1.97275f
C31 a_5946_4337.n1 GND 1.95827f
C32 a_6996_4337.n0 GND 1.6219f
C33 B04_OTA_0.Vin-.n0 GND 1.47726f
C34 B04_OTA_0.Vin-.n1 GND 1.20549f
C35 B04_OTA_0.Vin-.n2 GND 1.44288f
C36 B04_OTA_0.Vin-.n10 GND 1.97989f
C37 B04_OTA_0.Vbias3.n0 GND 7.73973f
C38 B04_OTA_0.Vbias3.t0 GND 1.57182f
C39 B04_OTA_0.Vbias3.t2 GND 1.37643f
C40 B04_OTA_0.Vbias3.n3 GND 1.0094f
C41 B04_OTA_0.Vbias3.n4 GND 2.16405f
C42 a_1974_4669.n0 GND 1.15674f
C43 a_1974_4669.n2 GND 2.5222f
C44 a_1974_4669.n5 GND 1.17455f
C45 a_1974_4669.n6 GND 1.04888f
C46 a_1974_4669.n7 GND 1.48237f
C47 a_3334_4669.n0 GND 1.28466f
C48 a_3334_4669.n1 GND 1.98473f
C49 a_3334_4669.n4 GND 1.34235f
C50 a_3334_4669.n5 GND 1.73854f
C51 a_3334_4669.n6 GND 1.48572f
C52 a_2584_2555.n1 GND 1.90045f
C53 a_2584_2555.n2 GND 1.01863f
C54 a_2584_2555.n4 GND 1.22206f
C55 B04_OTA_0.Vbias2.n9 GND 1.4952f
C56 B04_OTA_0.Vbias2.t0 GND 1.29331f
C57 B04_OTA_0.Vbias2.n10 GND 2.16521f
C58 a_2872_2967.n1 GND 2.44377f
C59 a_2872_2555.n0 GND 1.61198f
C60 a_2872_2555.n1 GND 3.22585f
C61 a_6630_n1720.t0 GND 1.37188f
C62 a_6630_n1720.t1 GND 1.37788f
C63 VDD.t47 GND 1.15978f
C64 VDD.n2 GND 1.25415f
C65 VDD.n5 GND 1.35065f
C66 VDD.t20 GND 2.41872f
C67 VDD.n9 GND 1.07114f
C68 VDD.n10 GND 2.4923f
C69 VDD.n12 GND 2.01755f
C70 VDD.n13 GND 1.84317f
C71 VDD.n40 GND 1.31883f
C72 VDD.t4 GND 1.54763f
C73 VDD.t39 GND 1.93244f
C74 VDD.t23 GND 1.93244f
C75 VDD.t26 GND 1.93244f
C76 VDD.t42 GND 1.46221f
C77 VDD.t1 GND 1.08676f
C78 VDD.t10 GND 1.13922f
C79 VDD.n44 GND 1.52402f
C80 VbiasN.t0 GND 2.3568f
.ends
