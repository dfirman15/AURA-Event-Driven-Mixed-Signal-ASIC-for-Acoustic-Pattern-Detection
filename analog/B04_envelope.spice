** sch_path: /foss/designs/AURA-Event-Driven-Mixed-Signal-ASIC-for-Acoustic-Pattern-Detection/analog/B04_envelope.sch
.subckt B04_envelope VDD Vin Vout VbiasN GND
*.PININFO VDD:B GND:B Vin:I Vout:O VbiasN:I
M1 VDD Vin Vout GND nfet_03v3 L=1u W=2u nf=1
M2 net2 VbiasN net1 GND nfet_03v3 L=4u W=0.5u nf=1
XC2 GND Vout cap_mim_2f0fF c_width=10u c_length=10u m=100
M3 net1 VbiasN GND GND nfet_03v3 L=4u W=0.5u nf=1
M4 net3 VbiasN net2 GND nfet_03v3 L=4u W=0.5u nf=1
M5 net4 VbiasN net3 GND nfet_03v3 L=4u W=0.5u nf=1
M6 Vout VbiasN net4 GND nfet_03v3 L=4u W=0.5u nf=1
.ends
