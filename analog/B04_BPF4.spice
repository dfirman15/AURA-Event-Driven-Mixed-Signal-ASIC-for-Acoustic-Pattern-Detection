** sch_path: /foss/designs/AURA-Event-Driven-Mixed-Signal-ASIC-for-Acoustic-Pattern-Detection/analog/B04_BPF4.sch
.subckt B04_BPF4 VDD GND Vin Vout VDD05 VbiasP VbiasN
*.PININFO VDD:B GND:B Vin:I Vout:O VDD05:I VbiasP:I VbiasN:I
x1 VDD VbiasP net1 net3 net4 net2 VbiasN GND B04_OTA_bias_ratio_025
x2 VDD VbiasP net5 net7 net8 net6 VbiasN GND B04_OTA_bias_ratio_025
x7 VDD VbiasP net9 net11 net12 net10 VbiasN GND B04_OTA_bias_ratio_04
x8 VDD VbiasP net13 net15 net16 net14 VbiasN GND B04_OTA_bias_ratio_04
x3 VDD net1 Vin VDD05 net4 net2 net18 net3 GND B04_OTA
x4 VDD net5 VDD05 net18 net8 net6 net18 net7 GND B04_OTA
x5 VDD net9 net18 VDD05 net12 net10 net19 net11 GND B04_OTA
x6 VDD net13 VDD05 net19 net16 net14 net18 net15 GND B04_OTA
x9 VDD net1 net18 VDD05 net4 net2 Vout net3 GND B04_OTA
x10 VDD net5 VDD05 Vout net8 net6 Vout net7 GND B04_OTA
x11 VDD net9 Vout VDD05 net12 net10 net17 net11 GND B04_OTA
x12 VDD net13 VDD05 net17 net16 net14 Vout net15 GND B04_OTA
XC1 net18 GND cap_mim_2f0fF c_width=10u c_length=10u m=64
XC2 net19 GND cap_mim_2f0fF c_width=10u c_length=10u m=64
XC3 Vout GND cap_mim_2f0fF c_width=10u c_length=10u m=64
XC4 net17 GND cap_mim_2f0fF c_width=10u c_length=10u m=64
XC5 GND GND cap_mim_2f0fF c_width=10u c_length=10u m=36
XC6 GND GND cap_mim_2f0fF c_width=10u c_length=10u m=36
XC7 GND GND cap_mim_2f0fF c_width=10u c_length=10u m=36
XC8 GND GND cap_mim_2f0fF c_width=10u c_length=10u m=36
**** begin user architecture code

.param m_cap=64

.param m_cap_1=30

**** end user architecture code
.ends

* expanding   symbol:  AURA-Event-Driven-Mixed-Signal-ASIC-for-Acoustic-Pattern-Detection/analog/B04_OTA_bias_ratio_025.sym # of
*+ pins=8
** sym_path: /foss/designs/AURA-Event-Driven-Mixed-Signal-ASIC-for-Acoustic-Pattern-Detection/analog/B04_OTA_bias_ratio_025.sym
** sch_path: /foss/designs/AURA-Event-Driven-Mixed-Signal-ASIC-for-Acoustic-Pattern-Detection/analog/B04_OTA_bias_ratio_025.sch
.subckt B04_OTA_bias_ratio_025 VDD VbiasP Vbias0 Vbias2 Vbias3 Vbias1 VbiasN GND
*.PININFO VDD:B Vbias2:O Vbias1:O Vbias0:O Vbias3:O GND:B VbiasP:I VbiasN:I
M1 Vbias1 GND Vbias2 VDD pfet_03v3 L=4u W=5u nf=1
M4 Vbias1 Vbias2 net1 GND nfet_03v3 L=4u W=1u nf=1
M5 net1 Vbias1 GND GND nfet_03v3 L=4u W=1u nf=1
M9 net2 Vbias3 Vbias0 VDD pfet_03v3 L=4u W=5u nf=1
M10 VDD Vbias0 net2 VDD pfet_03v3 L=4u W=5u nf=1
M6 Vbias3 VDD Vbias0 GND nfet_03v3 L=4u W=10u nf=1
M2 Vbias2 VbiasP VDD VDD pfet_03v3 L=4u W=1.25u nf=1
M3 GND VbiasN Vbias3 GND nfet_03v3 L=4u W=2.5u nf=1
.ends

* expanding   symbol:  AURA-Event-Driven-Mixed-Signal-ASIC-for-Acoustic-Pattern-Detection/analog/B04_OTA_bias_ratio_04.sym # of
*+ pins=8
** sym_path: /foss/designs/AURA-Event-Driven-Mixed-Signal-ASIC-for-Acoustic-Pattern-Detection/analog/B04_OTA_bias_ratio_04.sym
** sch_path: /foss/designs/AURA-Event-Driven-Mixed-Signal-ASIC-for-Acoustic-Pattern-Detection/analog/B04_OTA_bias_ratio_04.sch
.subckt B04_OTA_bias_ratio_04 VDD VbiasP Vbias0 Vbias2 Vbias3 Vbias1 VbiasN GND
*.PININFO VDD:B Vbias2:O Vbias1:O Vbias0:O Vbias3:O GND:B VbiasP:I VbiasN:I
M1 Vbias1 GND Vbias2 VDD pfet_03v3 L=4u W=5u nf=1
M4 Vbias1 Vbias2 net1 GND nfet_03v3 L=4u W=1u nf=1
M5 net1 Vbias1 GND GND nfet_03v3 L=4u W=1u nf=1
M9 net2 Vbias3 Vbias0 VDD pfet_03v3 L=4u W=5u nf=1
M10 VDD Vbias0 net2 VDD pfet_03v3 L=4u W=5u nf=1
M6 Vbias3 VDD Vbias0 GND nfet_03v3 L=4u W=10u nf=1
M2 Vbias2 VbiasP VDD VDD pfet_03v3 L=4u W=2u nf=1
M3 GND VbiasN Vbias3 GND nfet_03v3 L=4u W=4u nf=1
.ends

* expanding   symbol:  AURA-Event-Driven-Mixed-Signal-ASIC-for-Acoustic-Pattern-Detection/analog/B04_OTA.sym # of pins=9
** sym_path: /foss/designs/AURA-Event-Driven-Mixed-Signal-ASIC-for-Acoustic-Pattern-Detection/analog/B04_OTA.sym
** sch_path: /foss/designs/AURA-Event-Driven-Mixed-Signal-ASIC-for-Acoustic-Pattern-Detection/analog/B04_OTA.sch
.subckt B04_OTA VDD Vbias0 Vin+ Vin- Vbias3 Vbias1 Vout Vbias2 GND
*.PININFO VDD:B Vbias0:I Vin+:I Vin-:I Vout:O Vbias3:I Vbias2:I GND:B Vbias1:I
M1 net1 Vbias0 VDD VDD pfet_03v3 L=4u W=5u nf=1 m=2
M2 net6 Vin+ net1 VDD pfet_03v3 L=1u W=2u nf=1 m=9
M3 net7 Vin- net1 VDD pfet_03v3 L=1u W=2u nf=1 m=9
M4 net2 Vin+ net1 VDD pfet_03v3 L=1u W=2u nf=1
M5 net3 Vin- net1 VDD pfet_03v3 L=1u W=2u nf=1
M6 net2 Vbias2 net5 GND nfet_03v3 L=1u W=2u nf=1
M7 net3 Vbias2 net4 GND nfet_03v3 L=1u W=2u nf=1
M8 net5 net2 GND GND nfet_03v3 L=4u W=1u nf=1
M9 net6 net3 GND GND nfet_03v3 L=4u W=1u nf=1
M10 net4 net3 GND GND nfet_03v3 L=4u W=1u nf=1
M11 net7 net2 GND GND nfet_03v3 L=4u W=1u nf=1
M12 net9 net10 VDD VDD pfet_03v3 L=4u W=5u nf=1
M13 net8 net10 VDD VDD pfet_03v3 L=4u W=5u nf=1
M14 Vout Vbias3 net9 VDD pfet_03v3 L=4u W=5u nf=1
M15 net10 Vbias3 net8 VDD pfet_03v3 L=4u W=5u nf=1
M16 Vout Vbias2 net7 GND nfet_03v3 L=4u W=1u nf=1
M17 net10 Vbias2 net6 GND nfet_03v3 L=4u W=1u nf=1
M18 net6 Vbias1 GND GND nfet_03v3 L=4u W=1u nf=1 m=10
M19 net7 Vbias1 GND GND nfet_03v3 L=4u W=1u nf=1 m=10
Mdummy VDD VDD VDD VDD pfet_03v3 L=1u W=2u nf=1
Mdummy1 VDD VDD VDD VDD pfet_03v3 L=1u W=2u nf=1
Mdummy2 VDD VDD VDD VDD pfet_03v3 L=1u W=2u nf=1
Mdummy3 VDD VDD VDD VDD pfet_03v3 L=1u W=2u nf=1
Mdummy4 VDD VDD VDD VDD pfet_03v3 L=4u W=2.5u nf=1
Mdummy5 VDD VDD VDD VDD pfet_03v3 L=4u W=2.5u nf=1
Mdummy6 VDD VDD VDD VDD pfet_03v3 L=4u W=2.5u nf=1
Mdummy7 VDD VDD VDD VDD pfet_03v3 L=4u W=2.5u nf=1
Mdummy8 GND GND GND GND nfet_03v3 L=4u W=0.5u nf=1
Mdummy9 GND GND GND GND nfet_03v3 L=4u W=0.5u nf=1
Mdummy10 GND GND GND GND nfet_03v3 L=4u W=1u nf=1
Mdummy11 GND GND GND GND nfet_03v3 L=4u W=1u nf=1
Mdummy12 GND GND GND GND nfet_03v3 L=4u W=1u nf=1
Mdummy13 GND GND GND GND nfet_03v3 L=4u W=1u nf=1
Mdummy14 GND GND GND GND nfet_03v3 L=1u W=1u nf=1
Mdummy15 GND GND GND GND nfet_03v3 L=1u W=1u nf=1
Mdummy16 GND GND GND GND nfet_03v3 L=4u W=0.5u nf=1
Mdummy17 GND GND GND GND nfet_03v3 L=4u W=0.5u nf=1
Mdummy18 GND GND GND GND nfet_03v3 L=4u W=0.5u nf=1
Mdummy19 GND GND GND GND nfet_03v3 L=4u W=0.5u nf=1
.ends
