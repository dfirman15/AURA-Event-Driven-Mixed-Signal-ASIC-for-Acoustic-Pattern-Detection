** sch_path: /foss/designs/AURA-Event-Driven-Mixed-Signal-ASIC-for-Acoustic-Pattern-Detection/analog/B04_comparator.sch
.subckt B04_comparator VDD Q_BAR INN INP IB GND
*.PININFO VDD:B GND:B INN:I INP:I Q_BAR:O VbiasP:I
M1 net3 net1 GND GND nfet_03v3 L=0.56u W=1u nf=1
M2 net1 net1 GND GND nfet_03v3 L=0.56u W=1u nf=1
M3 net2 net2 GND GND nfet_03v3 L=0.56u W=1u nf=1
Mqqq net4 INN net3 GND nfet_03v3 L=0.28u W=2u nf=1
Mqqq1 net5 INP net3 GND nfet_03v3 L=0.28u W=2u nf=1
M6 Q_BAR net2 GND GND nfet_03v3 L=0.56u W=1u nf=1
Mq0 net4 net4 VDD VDD pfet_03v3 L=0.28u W=1.5u nf=1
Mq1 net2 net4 VDD VDD pfet_03v3 L=0.28u W=1.5u nf=1
Mq4 net4 net5 VDD VDD pfet_03v3 L=0.28u W=3.5u nf=1
Mq5 net5 net4 VDD VDD pfet_03v3 L=0.28u W=3.5u nf=1
Mq2 net5 net5 VDD VDD pfet_03v3 L=0.28u W=1.5u nf=1
Mq3 Q_BAR net5 VDD VDD pfet_03v3 L=0.28u W=1.5u nf=1
Mq6 VDD VbiasP net1 VDD pfet_03v3 L=4u W=2u nf=1
.ends
