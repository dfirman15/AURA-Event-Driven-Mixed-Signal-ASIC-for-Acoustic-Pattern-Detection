** sch_path: /foss/designs/AURA-Event-Driven-Mixed-Signal-ASIC-for-Acoustic-Pattern-Detection/analog/B04_AFE.sch
.subckt B04_AFE Vin VDD GND Vout VDD05
*.PININFO Vin:I VDD:B GND:B Vout:O VDD05:I
x5 VDD VbiasP net1 Vin GND B04_LNAv2
x3 VDD VbiasP VbiasN GND B04_BMR
x2 Vout net1 VDD05 B04_coupling
.ends

* expanding   symbol:  AURA-Event-Driven-Mixed-Signal-ASIC-for-Acoustic-Pattern-Detection/analog/B04_LNAv2.sym # of pins=5
** sym_path: /foss/designs/AURA-Event-Driven-Mixed-Signal-ASIC-for-Acoustic-Pattern-Detection/analog/B04_LNAv2.sym
** sch_path: /foss/designs/AURA-Event-Driven-Mixed-Signal-ASIC-for-Acoustic-Pattern-Detection/analog/B04_LNAv2.sch
.subckt B04_LNAv2 VDD VbiasP Vout Vin GND
*.PININFO VbiasP:I Vin:I VDD:B GND:B Vout:O
M1 Vout VbiasP VDD VDD pfet_03v3 L=4u W=1u nf=1 m=40
M2 Vout net1 GND GND nfet_03v3 L=1u W=40u nf=10 m=10
XC1 Vout net1 cap_mim_2f0fF c_width=10u c_length=10u
XC2 net1 Vin cap_mim_2f0fF c_width=10u c_length=10u m=20
M3 Vout Vout net1 net1 pfet_03v3 L=20u W=1u nf=1
M4 net1 net1 Vout Vout pfet_03v3 L=20u W=1u nf=1
.ends

* expanding   symbol:  AURA-Event-Driven-Mixed-Signal-ASIC-for-Acoustic-Pattern-Detection/analog/B04_BMR.sym # of pins=4
** sym_path: /foss/designs/AURA-Event-Driven-Mixed-Signal-ASIC-for-Acoustic-Pattern-Detection/analog/B04_BMR.sym
** sch_path: /foss/designs/AURA-Event-Driven-Mixed-Signal-ASIC-for-Acoustic-Pattern-Detection/analog/B04_BMR.sch
.subckt B04_BMR VDD VbiasP VbiasN GND
*.PININFO VDD:B GND:B VbiasP:O VbiasN:O
M2 VbiasN VbiasP VDD VDD pfet_03v3 L=4u W=1u nf=1 m=2
M3 net2 VbiasP VDD VDD pfet_03v3 L=4u W=1u nf=1 m=2
M6 VbiasN VbiasN GND GND nfet_03v3 L=4u W=10u nf=1
M7 net2 VbiasN net1 GND nfet_03v3 L=4u W=20u nf=2 m=2
M1 net4 net4 VDD VDD pfet_03v3 L=40u W=0.5u nf=1
M4 VbiasP net3 VbiasN GND nfet_03v3 L=1u W=1u nf=1
M5 net3 VbiasN GND GND nfet_03v3 L=1u W=20u nf=1
M8 net5 net5 net4 VDD pfet_03v3 L=40u W=0.5u nf=1
M9 net3 net3 net5 VDD pfet_03v3 L=40u W=0.5u nf=1
x1 VDD VbiasP net2 VbiasN VbiasN GND B04_diff_amp
XR1 GND net1 GND ppolyf_u_1k r_width=2u r_length=820u
Mdummy VDD VDD VDD VDD pfet_03v3 L=4u W=1u nf=1
Mdummy1 VDD VDD VDD VDD pfet_03v3 L=4u W=1u nf=1
Mdummy2 GND GND GND GND nfet_03v3 L=4u W=10u nf=1
Mdummy3 GND GND GND GND nfet_03v3 L=4u W=10u nf=1
XC1 VbiasP VbiasN cap_mim_2f0fF c_width=10u c_length=10u m=20
.ends

* expanding   symbol:  AURA-Event-Driven-Mixed-Signal-ASIC-for-Acoustic-Pattern-Detection/analog/B04_coupling.sym # of pins=3
** sym_path: /foss/designs/AURA-Event-Driven-Mixed-Signal-ASIC-for-Acoustic-Pattern-Detection/analog/B04_coupling.sym
** sch_path: /foss/designs/AURA-Event-Driven-Mixed-Signal-ASIC-for-Acoustic-Pattern-Detection/analog/B04_coupling.sch
.subckt B04_coupling Vout Vin VDD05
*.PININFO Vin:I VDD05:I Vout:O
XC1 Vin Vout cap_mim_2f0fF c_width=10u c_length=10u m=20
M3 VDD05 VDD05 Vout Vout pfet_03v3 L=4u W=0.5u nf=1
M4 Vout Vout VDD05 VDD05 pfet_03v3 L=4u W=0.5u nf=1
.ends

* expanding   symbol:  AURA-Event-Driven-Mixed-Signal-ASIC-for-Acoustic-Pattern-Detection/analog/B04_diff_amp.sym # of pins=6
** sym_path: /foss/designs/AURA-Event-Driven-Mixed-Signal-ASIC-for-Acoustic-Pattern-Detection/analog/B04_diff_amp.sym
** sch_path: /foss/designs/AURA-Event-Driven-Mixed-Signal-ASIC-for-Acoustic-Pattern-Detection/analog/B04_diff_amp.sch
.subckt B04_diff_amp VDD Vo V+ V- Vbias VSS
*.PININFO VDD:B VSS:B V+:I V-:I Vo:O Vbias:I
M1 net1 V+ net2 VSS nfet_03v3 L=4u W=0.55u nf=1 m=2
M2 net2 Vbias VSS VSS nfet_03v3 L=4u W=2.2u nf=1
M3 Vo V- net2 VSS nfet_03v3 L=4u W=0.55u nf=1 m=2
M4 Vo net1 VDD VDD pfet_03v3 L=4u W=6.5u nf=1 m=2
M5 net1 net1 VDD VDD pfet_03v3 L=4u W=6.5u nf=1 m=2
MDummy VDD VDD VDD VDD pfet_03v3 L=4u W=6.5u nf=1
MDummy1 VDD VDD VDD VDD pfet_03v3 L=4u W=6.5u nf=1
Mdummy2 VSS VSS VSS VSS nfet_03v3 L=4u W=0.55u nf=1
Mdummy3 VSS VSS VSS VSS nfet_03v3 L=4u W=0.55u nf=1
.ends
