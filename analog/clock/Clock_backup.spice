* NGSPICE file created from Clock_backup.ext - technology: gf180mcuD

.subckt cap_mim_2p0fF_G3UYSM m4_n1240_n1620#
X0 m4_n1120_n1500# m4_n1240_n1620# cap_mim_2f0_m4m5_noshield c_width=10u c_length=15u
.ends

.subckt pfet_03v3_54Z2EE a_100_n50# a_n100_n142# a_n188_n50# w_n350_n260#
X0 a_100_n50# a_n100_n142# a_n188_n50# w_n350_n260# pfet_03v3 ad=0.22p pd=1.88u as=0.22p ps=1.88u w=0.5u l=1u
.ends

.subckt nfet_03v3_REA3EN a_100_n50# a_n326_n236# a_n100_n142# a_n188_n50#
X0 a_100_n50# a_n100_n142# a_n188_n50# a_n326_n236# nfet_03v3 ad=0.22p pd=1.88u as=0.22p ps=1.88u w=0.5u l=1u
.ends

.subckt pfet_03v3_AVNSD5 a_100_n50# a_n100_n142# a_n188_n50# w_n350_n260#
X0 a_100_n50# a_n100_n142# a_n188_n50# w_n350_n260# pfet_03v3 ad=0.22p pd=1.88u as=0.22p ps=1.88u w=0.5u l=1u
.ends

.subckt pfet_03v3_GPEX9R a_n1088_n50# a_1000_n50# w_n1250_n260# a_n1000_n142#
X0 a_1000_n50# a_n1000_n142# a_n1088_n50# w_n1250_n260# pfet_03v3 ad=0.22p pd=1.88u as=0.22p ps=1.88u w=0.5u l=10u
.ends

.subckt nfet_03v3_5P2FD6 a_n2000_n142# a_n2088_n50# a_n2226_n236# a_2000_n50#
X0 a_2000_n50# a_n2000_n142# a_n2088_n50# a_n2226_n236# nfet_03v3 ad=0.22p pd=1.88u as=0.22p ps=1.88u w=0.5u l=20u
.ends

.subckt pfet_03v3_C5NPLE a_n2788_n50# a_2700_n50# w_n2950_n260# a_n2700_n142#
X0 a_2700_n50# a_n2700_n142# a_n2788_n50# w_n2950_n260# pfet_03v3 ad=0.22p pd=1.88u as=0.22p ps=1.88u w=0.5u l=27u
.ends

.subckt pfet_03v3_9TRV9F a_n188_n100# a_n100_n192# a_100_n100# w_n350_n310#
X0 a_100_n100# a_n100_n192# a_n188_n100# w_n350_n310# pfet_03v3 ad=0.44p pd=2.88u as=0.44p ps=2.88u w=1u l=1u
.ends

.subckt nfet_03v3_Y6NWY5 a_n2788_n50# a_n2926_n236# a_2700_n50# a_n2700_n142#
X0 a_2700_n50# a_n2700_n142# a_n2788_n50# a_n2926_n236# nfet_03v3 ad=0.22p pd=1.88u as=0.22p ps=1.88u w=0.5u l=27u
.ends

.subckt nfet_03v3_GNRYRW a_n188_n100# a_n100_n192# a_100_n100# a_n326_n286#
X0 a_100_n100# a_n100_n192# a_n188_n100# a_n326_n286# nfet_03v3 ad=0.44p pd=2.88u as=0.44p ps=2.88u w=1u l=1u
.ends

.subckt B04_schmitt_trigger_backup VDD Vin Vout m2_2380_n1660# GND
XXM1 m1_2940_n3770# m1_8470_n3020# VDD Vin pfet_03v3_C5NPLE
XXM2 m1_2940_n3770# Vout VDD Vin pfet_03v3_C5NPLE
XXM3 m1_2940_n3770# Vout GND VDD pfet_03v3_9TRV9F
XXM4 m1_2950_n5450# GND Vout Vin nfet_03v3_Y6NWY5
XXM5 m1_2950_n5450# GND GND Vin nfet_03v3_Y6NWY5
XXM6 m1_2950_n5450# Vout VDD GND nfet_03v3_GNRYRW
XXM7 VDD m1_8470_n3020# VDD GND pfet_03v3_C5NPLE
XXM8 GND GND GND VDD nfet_03v3_Y6NWY5
.ends

.subckt Clock_backup VDD Vout GND
Xcap_mim_2f0fF GND cap_mim_2p0fF_G3UYSM
XXM1 Vout m1_8300_1780# VDD VDD pfet_03v3_54Z2EE
XXM2 GND GND B04_schmitt_trigger_backup_0/Vout m1_8300_1780# nfet_03v3_REA3EN
XXM3 m1_8300_1780# B04_schmitt_trigger_backup_0/Vout VDD VDD pfet_03v3_AVNSD5
XXM4 GND GND m1_8300_1780# Vout nfet_03v3_REA3EN
XXM5 GND Vout VDD GND pfet_03v3_GPEX9R
XXM6 VDD GND GND Vout nfet_03v3_5P2FD6
XB04_schmitt_trigger_backup_0 VDD GND B04_schmitt_trigger_backup_0/Vout m2_n20_5150#
+ GND B04_schmitt_trigger_backup
.ends
