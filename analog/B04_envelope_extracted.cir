* Extracted by KLayout with GF180MCU LVS runset on : 02/08/2026 13:35

.SUBCKT B04_envelope GND Vout Vin VDD
M$1 \$11 \$11 VDD VDD pfet_03v3 L=5U W=1U AS=0.44P AD=0.44P PS=2.88U PD=2.88U
M$2 \$12 \$12 \$19 \$19 pfet_03v3 L=5U W=1U AS=0.44P AD=0.44P PS=2.88U PD=2.88U
M$3 \$6 \$6 \$12 \$12 pfet_03v3 L=5U W=1U AS=0.44P AD=0.44P PS=2.88U PD=2.88U
M$4 \$19 \$19 \$11 \$11 pfet_03v3 L=5U W=1U AS=0.44P AD=0.44P PS=2.88U PD=2.88U
M$5 \$6 \$6 GND GND nfet_03v3 L=4U W=5U AS=1.48P AD=1.48P PS=8.96U PD=8.96U
M$10 GND \$6 Vout GND nfet_03v3 L=4U W=7U AS=3.08P AD=3.08P PS=14.88U PD=14.88U
M$11 Vout Vin VDD GND nfet_03v3 L=1U W=2U AS=0.88P AD=0.88P PS=4.88U PD=4.88U
.ENDS B04_envelope
