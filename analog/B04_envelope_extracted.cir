* Extracted by KLayout with GF180MCU LVS runset on : 03/09/2026 16:00

.SUBCKT B04_envelope Vout VDD Vin VbiasN GND
D$1 Vout VDD diode_pd2nw_03v3 A=5P P=20U
C$6 GND Vout 2e-11 cap_mim_2f0fF A=10000P P=4000U
M$106 Vout Vin VDD GND nfet_03v3 L=1U W=2U AS=0.88P AD=0.88P PS=4.88U PD=4.88U
M$107 \$214 VbiasN Vout GND nfet_03v3 L=4U W=0.5U AS=0.22P AD=0.22P PS=1.88U
+ PD=1.88U
M$108 \$206 VbiasN \$204 GND nfet_03v3 L=4U W=0.5U AS=0.22P AD=0.22P PS=1.88U
+ PD=1.88U
M$109 GND VbiasN \$204 GND nfet_03v3 L=4U W=0.5U AS=0.22P AD=0.22P PS=1.88U
+ PD=1.88U
M$110 \$206 VbiasN \$205 GND nfet_03v3 L=4U W=0.5U AS=0.22P AD=0.22P PS=1.88U
+ PD=1.88U
M$111 \$214 VbiasN \$205 GND nfet_03v3 L=4U W=0.5U AS=0.22P AD=0.22P PS=1.88U
+ PD=1.88U
D$112 GND Vout diode_nd2ps_03v3 A=5P P=20U
.ENDS B04_envelope
