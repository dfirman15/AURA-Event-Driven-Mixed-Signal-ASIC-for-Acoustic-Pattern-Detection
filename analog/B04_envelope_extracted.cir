* Extracted by KLayout with GF180MCU LVS runset on : 03/08/2026 05:15

.SUBCKT B04_envelope Vout Vin VDD GND
C$1 Vout GND 2e-11 cap_mim_2f0fF A=10000P P=4000U
M$101 \$384 \$384 VDD VDD pfet_03v3 L=5U W=1U AS=0.44P AD=0.44P PS=2.88U
+ PD=2.88U
M$102 \$396 \$396 \$384 \$384 pfet_03v3 L=5U W=1U AS=0.44P AD=0.44P PS=2.88U
+ PD=2.88U
M$103 \$385 \$385 \$396 \$396 pfet_03v3 L=5U W=1U AS=0.44P AD=0.44P PS=2.88U
+ PD=2.88U
M$104 \$392 \$392 \$385 \$385 pfet_03v3 L=5U W=1U AS=0.44P AD=0.44P PS=2.88U
+ PD=2.88U
M$105 \$392 \$392 GND GND nfet_03v3 L=4U W=5U AS=1.48P AD=1.48P PS=8.96U
+ PD=8.96U
M$110 GND \$392 Vout GND nfet_03v3 L=4U W=7U AS=3.08P AD=3.08P PS=14.88U
+ PD=14.88U
M$111 Vout Vin VDD GND nfet_03v3 L=1U W=2U AS=0.88P AD=0.88P PS=4.88U PD=4.88U
.ENDS B04_envelope
