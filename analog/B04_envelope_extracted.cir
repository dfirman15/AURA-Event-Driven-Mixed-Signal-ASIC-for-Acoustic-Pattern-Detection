* Extracted by KLayout with GF180MCU LVS runset on : 17/08/2026 09:07

.SUBCKT B04_envelope Vout VDD Vin VbiasN GND
C$1 GND Vout 2e-11 cap_mim_2f0fF A=10000P P=4000U
M$101 Vout Vin VDD GND nfet_03v3 L=1U W=2U AS=0.88P AD=0.88P PS=4.88U PD=4.88U
M$102 \$203 VbiasN Vout GND nfet_03v3 L=4U W=0.5U AS=0.22P AD=0.22P PS=1.88U
+ PD=1.88U
M$103 \$189 VbiasN \$192 GND nfet_03v3 L=4U W=0.5U AS=0.22P AD=0.22P PS=1.88U
+ PD=1.88U
M$104 \$189 VbiasN \$202 GND nfet_03v3 L=4U W=0.5U AS=0.22P AD=0.22P PS=1.88U
+ PD=1.88U
M$105 GND VbiasN \$192 GND nfet_03v3 L=4U W=0.5U AS=0.22P AD=0.22P PS=1.88U
+ PD=1.88U
M$106 \$203 VbiasN \$202 GND nfet_03v3 L=4U W=0.5U AS=0.22P AD=0.22P PS=1.88U
+ PD=1.88U
.ENDS B04_envelope
