* Extracted by KLayout with GF180MCU LVS runset on : 13/08/2026 04:16

.SUBCKT B04_OTA_bias_ratio_04 Vbias3 VbiasN VDD Vbias1 Vbias0 Vbias2 VbiasP GND
M$1 Vbias2 VbiasP VDD VDD pfet_03v3 L=4U W=2U AS=0.88P AD=0.88P PS=4.88U
+ PD=4.88U
M$2 Vbias3 VbiasN GND GND nfet_03v3 L=4U W=4U AS=1.76P AD=1.76P PS=8.88U
+ PD=8.88U
M$3 \$9 Vbias1 GND GND nfet_03v3 L=4U W=1U AS=0.44P AD=0.44P PS=2.88U PD=2.88U
M$4 Vbias1 Vbias2 \$9 GND nfet_03v3 L=4U W=1U AS=0.44P AD=0.44P PS=2.88U
+ PD=2.88U
M$5 Vbias3 VDD Vbias0 GND nfet_03v3 L=4U W=10U AS=4.4P AD=4.4P PS=20.88U
+ PD=20.88U
M$6 Vbias0 Vbias3 \$13 VDD pfet_03v3 L=4U W=5U AS=2.2P AD=2.2P PS=10.88U
+ PD=10.88U
M$7 \$13 Vbias0 VDD VDD pfet_03v3 L=4U W=5U AS=2.2P AD=2.2P PS=10.88U PD=10.88U
M$8 Vbias1 GND Vbias2 VDD pfet_03v3 L=4U W=5U AS=2.2P AD=2.2P PS=10.88U
+ PD=10.88U
.ENDS B04_OTA_bias_ratio_04
