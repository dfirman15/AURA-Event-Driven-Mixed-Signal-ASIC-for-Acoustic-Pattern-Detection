* Extracted by KLayout with GF180MCU LVS runset on : 06/08/2026 18:58

.SUBCKT B04_LNA SUB \$21.VbiasN \$21.VbiasP
X$22 \$6 \$81 \$699 \$5 \$8 \$1460 \$202 \$7 SUB B04_LNA_OTA
C$1 \$1 \$8 2e-12 cap_mim_2f0fF A=1000P P=400U
C$2 \$2 \$202 2e-12 cap_mim_2f0fF A=1000P P=400U
C$21 \$699 \$8 2e-13 cap_mim_2f0fF A=100P P=40U
C$22 \$326 \$202 2e-13 cap_mim_2f0fF A=100P P=40U
M$23 \$8 \$773 \$773 \$8 pfet_03v3 L=4U W=1U AS=0.44P AD=0.44P PS=2.88U PD=2.88U
M$24 \$202 \$458 \$458 \$202 pfet_03v3 L=4U W=1U AS=0.44P AD=0.44P PS=2.88U
+ PD=2.88U
M$25 \$326 \$458 \$458 \$326 pfet_03v3 L=4U W=1U AS=0.44P AD=0.44P PS=2.88U
+ PD=2.88U
M$26 \$699 \$773 \$773 \$699 pfet_03v3 L=4U W=1U AS=0.44P AD=0.44P PS=2.88U
+ PD=2.88U
M$27 \$81 \$21.VbiasP \$5 \$5 pfet_03v3 L=4U W=40U AS=17.6P AD=17.6P PS=80.88U
+ PD=80.88U
M$28 \$1460 \$21.VbiasN SUB SUB nfet_03v3 L=4U W=80U AS=35.2P AD=35.2P
+ PS=160.88U PD=160.88U
M$29 \$I3184 \$6 SUB SUB nfet_03v3 L=4U W=1U AS=0.44P AD=0.44P PS=2.88U PD=2.88U
M$30 \$6 \$81 \$I3184 SUB nfet_03v3 L=4U W=1U AS=0.44P AD=0.44P PS=2.88U
+ PD=2.88U
M$31 \$1460 \$5 \$7 SUB nfet_03v3 L=4U W=10U AS=4.4P AD=4.4P PS=20.88U PD=20.88U
M$32 \$7 \$1460 \$I3185 \$5 pfet_03v3 L=4U W=5U AS=2.2P AD=2.2P PS=10.88U
+ PD=10.88U
M$33 \$I3185 \$7 \$5 \$5 pfet_03v3 L=4U W=5U AS=2.2P AD=2.2P PS=10.88U PD=10.88U
M$34 \$6 SUB \$81 \$5 pfet_03v3 L=4U W=5U AS=2.2P AD=2.2P PS=10.88U PD=10.88U
.ENDS B04_LNA

.SUBCKT B04_LNA_OTA \$2 \$5 \$10 \$27 \$43 \$44 \$45 \$48 SUB
M$1 \$3 \$2 SUB SUB nfet_03v3 L=8U W=20U AS=5.92P AD=5.92P PS=29.92U PD=29.92U
M$6 SUB \$2 \$4 SUB nfet_03v3 L=8U W=20U AS=5.92P AD=5.92P PS=29.92U PD=29.92U
M$21 \$46 \$48 \$27 \$27 pfet_03v3 L=4U W=10U AS=3.5P AD=3.5P PS=16.4U PD=16.4U
M$23 \$9 \$44 \$41 \$27 pfet_03v3 L=8U W=10U AS=4.4P AD=4.4P PS=20.88U PD=20.88U
M$24 \$42 \$9 \$27 \$27 pfet_03v3 L=8U W=10U AS=4.4P AD=4.4P PS=20.88U PD=20.88U
M$25 \$27 \$9 \$41 \$27 pfet_03v3 L=8U W=10U AS=4.4P AD=4.4P PS=20.88U PD=20.88U
M$26 \$42 \$44 \$10 \$27 pfet_03v3 L=8U W=10U AS=4.4P AD=4.4P PS=20.88U
+ PD=20.88U
M$27 \$25 \$5 \$6 SUB nfet_03v3 L=2U W=4U AS=1.76P AD=1.76P PS=8.88U PD=8.88U
M$28 \$7 \$5 \$11 SUB nfet_03v3 L=2U W=4U AS=1.76P AD=1.76P PS=8.88U PD=8.88U
M$29 SUB \$25 \$3 SUB nfet_03v3 L=8U W=2U AS=0.88P AD=0.88P PS=4.88U PD=4.88U
M$30 \$3 \$5 \$10 SUB nfet_03v3 L=8U W=2U AS=0.88P AD=0.88P PS=4.88U PD=4.88U
M$31 \$9 \$5 \$4 SUB nfet_03v3 L=8U W=2U AS=0.88P AD=0.88P PS=4.88U PD=4.88U
M$32 \$4 \$11 SUB SUB nfet_03v3 L=8U W=2U AS=0.88P AD=0.88P PS=4.88U PD=4.88U
M$33 SUB \$25 \$6 SUB nfet_03v3 L=8U W=2U AS=0.88P AD=0.88P PS=4.88U PD=4.88U
M$34 \$7 \$11 SUB SUB nfet_03v3 L=8U W=2U AS=0.88P AD=0.88P PS=4.88U PD=4.88U
M$35 \$3 \$43 \$46 \$27 pfet_03v3 L=8U W=144U AS=43.2P AD=43.2P PS=181.4U
+ PD=181.4U
M$40 \$46 \$45 \$4 \$27 pfet_03v3 L=8U W=144U AS=43.2P AD=43.2P PS=181.4U
+ PD=181.4U
M$53 \$46 \$43 \$11 \$27 pfet_03v3 L=8U W=16U AS=7.04P AD=7.04P PS=32.88U
+ PD=32.88U
M$54 \$25 \$45 \$46 \$27 pfet_03v3 L=8U W=16U AS=7.04P AD=7.04P PS=32.88U
+ PD=32.88U
M$55 \$27 \$27 \$27 \$27 pfet_03v3 L=8U W=32U AS=14.08P AD=14.08P PS=65.76U
+ PD=65.76U
.ENDS B04_LNA_OTA
