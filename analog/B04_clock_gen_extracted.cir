* Extracted by KLayout with GF180MCU LVS runset on : 28/08/2026 21:17

.SUBCKT B04_clock_gen En Vout VDD GND
C$1 \$1 GND 4.8e-12 cap_mim_2f0fF A=2400P P=720U
M$13 \$22 VDD \$1 GND nfet_03v3 L=20U W=0.5U AS=0.22P AD=0.22P PS=1.88U PD=1.88U
M$14 \$22 GND \$1 VDD pfet_03v3 L=10U W=0.5U AS=0.22P AD=0.22P PS=1.88U PD=1.88U
M$15 \$20 \$17 VDD VDD pfet_03v3 L=1U W=0.5U AS=0.22P AD=0.22P PS=1.88U PD=1.88U
M$16 \$19 En \$20 \$20 pfet_03v3 L=1U W=0.5U AS=0.22P AD=0.22P PS=1.88U PD=1.88U
M$17 \$22 \$19 VDD VDD pfet_03v3 L=1U W=0.5U AS=0.22P AD=0.22P PS=1.88U PD=1.88U
M$18 Vout \$22 VDD VDD pfet_03v3 L=1U W=0.5U AS=0.22P AD=0.22P PS=1.88U PD=1.88U
M$19 GND \$17 \$19 GND nfet_03v3 L=1U W=0.5U AS=0.22P AD=0.22P PS=1.88U PD=1.88U
M$20 GND En \$19 GND nfet_03v3 L=1U W=0.5U AS=0.22P AD=0.22P PS=1.88U PD=1.88U
M$21 GND \$19 \$22 GND nfet_03v3 L=1U W=0.5U AS=0.22P AD=0.22P PS=1.88U PD=1.88U
M$22 GND \$22 Vout GND nfet_03v3 L=1U W=0.5U AS=0.22P AD=0.22P PS=1.88U PD=1.88U
M$23 VDD \$17 \$I64 GND nfet_03v3 L=1U W=1U AS=0.44P AD=0.44P PS=2.88U PD=2.88U
M$24 GND VDD GND GND nfet_03v3 L=27U W=0.5U AS=0.22P AD=0.22P PS=1.88U PD=1.88U
M$25 GND \$1 \$I64 GND nfet_03v3 L=27U W=0.5U AS=0.22P AD=0.22P PS=1.88U
+ PD=1.88U
M$26 \$17 \$1 \$I64 GND nfet_03v3 L=27U W=0.5U AS=0.22P AD=0.22P PS=1.88U
+ PD=1.88U
M$27 GND \$17 \$I65 VDD pfet_03v3 L=1U W=1U AS=0.44P AD=0.44P PS=2.88U PD=2.88U
M$28 \$I66 \$1 \$I65 VDD pfet_03v3 L=27U W=0.5U AS=0.22P AD=0.22P PS=1.88U
+ PD=1.88U
M$29 \$I66 GND VDD VDD pfet_03v3 L=27U W=0.5U AS=0.22P AD=0.22P PS=1.88U
+ PD=1.88U
M$30 \$17 \$1 \$I65 VDD pfet_03v3 L=27U W=0.5U AS=0.22P AD=0.22P PS=1.88U
+ PD=1.88U
.ENDS B04_clock_gen
