* NGSPICE file created from B04_VDD05.ext - technology: gf180mcuD

.subckt pfet_03v3_AERJ7T w_n650_n710# a_n488_n500# a_n400_n592# a_400_n500# VSUBS
X0 a_400_n500# a_n400_n592# a_n488_n500# w_n650_n710# pfet_03v3 ad=2.2p pd=10.88u as=2.2p ps=10.88u w=5u l=4u
C0 a_400_n500# w_n650_n710# 0.71407f
C1 a_n400_n592# w_n650_n710# 2.78724f
C2 a_n488_n500# w_n650_n710# 0.71407f
C3 a_400_n500# a_n400_n592# 0.17653f
C4 a_n488_n500# a_n400_n592# 0.17653f
C5 a_n400_n592# VSUBS 0.18943f
C6 w_n650_n710# VSUBS 6.36214f
.ends

.subckt pfet_03v3_Z6KXZE w_n650_n2710# a_400_n2500# a_n488_n2500# a_n400_n2592# VSUBS
X0 a_400_n2500# a_n400_n2592# a_n488_n2500# w_n650_n2710# pfet_03v3 ad=11p pd=50.88u as=11p ps=50.88u w=25u l=4u
C0 a_400_n2500# w_n650_n2710# 3.46966f
C1 a_n400_n2592# w_n650_n2710# 2.8049f
C2 a_n488_n2500# w_n650_n2710# 3.46966f
C3 a_400_n2500# a_n400_n2592# 0.88549f
C4 a_n488_n2500# a_400_n2500# 0.25471f
C5 a_n488_n2500# a_n400_n2592# 0.88549f
C6 a_n400_n2592# VSUBS 0.23142f
C7 w_n650_n2710# VSUBS 23.3294f
.ends

.subckt nfet_03v3_FFLZC7 a_n488_n5000# a_n400_n5092# w_n650_n5210# a_400_n5000#
X0 a_400_n5000# a_n400_n5092# a_n488_n5000# w_n650_n5210# nfet_03v3 ad=22p pd=0.10088m as=22p ps=0.10088m w=50u l=4u
C0 a_n488_n5000# a_n400_n5092# 1.77169f
C1 a_400_n5000# a_n400_n5092# 1.77169f
C2 a_400_n5000# a_n488_n5000# 0.50962f
C3 a_400_n5000# w_n650_n5210# 5.32419f
C4 a_n488_n5000# w_n650_n5210# 5.32419f
C5 a_n400_n5092# w_n650_n5210# 2.78216f
.ends

.subckt nfet_03v3_REC73X a_n488_n100# a_n400_n192# a_400_n100# w_n650_n310#
X0 a_400_n100# a_n400_n192# a_n488_n100# w_n650_n310# nfet_03v3 ad=0.44p pd=2.88u as=0.44p ps=2.88u w=1u l=4u
C0 a_400_n100# w_n650_n310# 0.14396f
C1 a_n488_n100# w_n650_n310# 0.14396f
C2 a_n400_n192# w_n650_n310# 2.73979f
.ends

.subckt nfet_03v3_GPTQ69 a_n400_n1092# w_n650_n1210# a_400_n1000# a_n488_n1000#
X0 a_400_n1000# a_n400_n1092# a_n488_n1000# w_n650_n1210# nfet_03v3 ad=4.4p pd=20.88u as=4.4p ps=20.88u w=10u l=4u
C0 a_n488_n1000# a_n400_n1092# 0.35377f
C1 a_400_n1000# a_n400_n1092# 0.35377f
C2 a_400_n1000# a_n488_n1000# 0.10176f
C3 a_400_n1000# w_n650_n1210# 1.10097f
C4 a_n488_n1000# w_n650_n1210# 1.10097f
C5 a_n400_n1092# w_n650_n1210# 2.78216f
.ends

.subckt B04_OTA_bias_ratio_5 Vbias2 Vbias1 Vbias0 Vbias3 VbiasP VbiasN GND VDD
XXM1 VDD Vbias2 GND Vbias1 GND pfet_03v3_AERJ7T
XXM2 VDD Vbias2 VDD VbiasP GND pfet_03v3_Z6KXZE
XXM3 GND VbiasN GND Vbias3 nfet_03v3_FFLZC7
XXM4 m1_960_n780# Vbias2 Vbias1 GND nfet_03v3_REC73X
XXM5 GND Vbias1 m1_960_n780# GND nfet_03v3_REC73X
XXM6 VDD GND Vbias3 Vbias0 nfet_03v3_GPTQ69
XXM9 VDD m1_4120_180# Vbias3 Vbias0 GND pfet_03v3_AERJ7T
XXM10 VDD VDD Vbias0 m1_4120_180# GND pfet_03v3_AERJ7T
R0 GND.n7 GND.n6 155027
R1 GND.n12 GND.n7 143975
R2 GND.n19 GND.n7 15545.8
R3 GND.n20 GND.n19 1013.09
R4 GND.n18 GND.n8 956.36
R5 GND.n12 GND.n8 342.507
R6 GND.n19 GND.n18 170.2
R7 GND.n20 GND.n6 153.99
R8 GND.n17 GND.n9 78.1672
R9 GND.n3 GND.n0 7.64518
R10 GND GND.n23 7.06029
R11 GND.n11 GND.n10 4.74041
R12 GND.n4 GND.n3 4.47312
R13 GND.n23 GND.n1 2.24034
R14 GND.n15 GND.n14 2.1876
R15 GND.n16 GND.n11 1.38792
R16 GND.n13 GND.n9 1.3005
R17 GND.n9 GND.n8 1.3005
R18 GND.n17 GND.n16 1.3005
R19 GND.n18 GND.n17 1.3005
R20 GND.n13 GND.n11 1.28485
R21 GND.n4 GND.n1 1.04767
R22 GND.n14 GND.n12 0.633572
R23 GND.n22 GND.n21 0.452559
R24 GND.n21 GND.n4 0.452559
R25 GND GND.n0 0.388735
R26 GND.n16 GND.n15 0.313543
R27 GND.n23 GND.n22 0.175366
R28 GND.n3 GND.n2 0.153074
R29 GND.n5 GND.n0 0.0972879
R30 GND.n5 GND.n2 0.0972879
R31 GND.n15 GND.n1 0.0898576
R32 GND.n14 GND.n13 0.0885435
R33 GND.n22 GND.n2 0.0309813
R34 GND.n21 GND.n20 0.0013077
R35 GND.n6 GND.n5 0.00100418
R36 VbiasN VbiasN.n0 25.7454
R37 Vbias3 Vbias3.n0 3.64203
R38 Vbias0 Vbias0.n0 3.58275
R39 Vbias1 Vbias1.n0 8.35681
R40 Vbias2.n1 Vbias2.n0 5.02355
R41 Vbias2 Vbias2.n1 0.152808
R42 Vbias2.n1 Vbias2 0.1105
R43 VbiasP VbiasP.n0 13.282
R44 VDD VDD.n0 10.4141
C0 m1_4120_180# Vbias0 0.36809f
C1 VbiasN Vbias3 2.95478f
C2 VDD Vbias1 0.23821f
C3 VDD Vbias0 1.50174f
C4 Vbias2 Vbias1 0.27823f
C5 m1_960_n780# Vbias1 0.25758f
C6 Vbias3 Vbias0 1.2
