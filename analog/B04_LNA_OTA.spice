** sch_path: /foss/designs/AURA-Event-Driven-Mixed-Signal-ASIC-for-Acoustic-Pattern-Detection/analog/B04_LNA_OTA.sch
.subckt B04_LNA_OTA VDD Vbias0 Vin+ Vin- Vbias3 Vbias1 Vout Vbias2 GND
*.PININFO VDD:B Vbias0:I Vin+:I Vin-:I Vout:O Vbias3:I Vbias2:I GND:B Vbias1:I
M1 net1 Vbias0 VDD VDD pfet_03v3 L=4u W=10u nf=1
M2 net6 Vin+ net1 VDD pfet_03v3 L=8u W=144u nf=1
M3 net7 Vin- net1 VDD pfet_03v3 L=8u W=144u nf=1
M4 net2 Vin+ net1 VDD pfet_03v3 L=8u W=16u nf=1
M5 net3 Vin- net1 VDD pfet_03v3 L=8u W=16u nf=1
M6 net2 Vbias2 net5 GND nfet_03v3 L=2u W=4u nf=1
M7 net3 Vbias2 net4 GND nfet_03v3 L=2u W=4u nf=1
M8 net5 net2 GND GND nfet_03v3 L=8u W=2u nf=1
M9 net6 net3 GND GND nfet_03v3 L=8u W=2u nf=1
M10 net4 net3 GND GND nfet_03v3 L=8u W=2u nf=1
M11 net7 net2 GND GND nfet_03v3 L=8u W=2u nf=1
M12 net9 net10 VDD VDD pfet_03v3 L=8u W=10u nf=1
M13 net8 net10 VDD VDD pfet_03v3 L=8u W=10u nf=1
M14 Vout Vbias3 net9 VDD pfet_03v3 L=8u W=10u nf=1
M15 net10 Vbias3 net8 VDD pfet_03v3 L=8u W=10u nf=1
M16 Vout Vbias2 net7 GND nfet_03v3 L=8u W=2u nf=1
M17 net10 Vbias2 net6 GND nfet_03v3 L=8u W=2u nf=1
M18 net6 Vbias1 GND GND nfet_03v3 L=8u W=20u nf=1
M19 net7 Vbias1 GND GND nfet_03v3 L=8u W=20u nf=1
M20 VDD VDD VDD VDD pfet_03v3 L=8u W=16u nf=1
M21 VDD VDD VDD VDD pfet_03v3 L=8u W=16u nf=1
.ends
